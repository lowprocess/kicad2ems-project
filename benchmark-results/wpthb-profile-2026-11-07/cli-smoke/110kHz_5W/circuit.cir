Transient power circuit
VSUP n2 0 24
V_RSOURCE n2 n3 0
R_RSOURCE n3 n4 0.050000000000000003
V_LSOURCE n4 n5 0
L_LSOURCE n5 n6 9.9999999999999995e-08 IC=0.22826545352309302
V_C19 0 n7 0
R_C19_series n7 n9 0.0050000000000000001
L_C19_series n9 n10 8.0000000000000003e-10
C_C19 n10 n8 9.9999999999999995e-07 IC=-23.980597436450537
V_C20 0 n11 0
R_C20_series n11 n12 0.0050000000000000001
L_C20_series n12 n13 8.0000000000000003e-10
C_C20 n13 n8 1.0000000000000001e-05 IC=-23.980597436450537
V_C21 0 n14 0
R_C21_series n14 n15 0.0050000000000000001
L_C21_series n15 n16 8.0000000000000003e-10
C_C21 n16 n8 1.0000000000000001e-05 IC=-23.980597436450537
V_C22 0 n17 0
R_C22_series n17 n18 0.0050000000000000001
L_C22_series n18 n19 8.0000000000000003e-10
C_C22 n19 n8 1.0000000000000001e-05 IC=-23.980597436450537
V_C23 0 n20 0
R_C23_series n20 n21 0.0050000000000000001
L_C23_series n21 n22 8.0000000000000003e-10
C_C23 n22 n8 1.0000000000000001e-05 IC=-23.980597436450537
V_C24 0 n23 0
R_C24_series n23 n24 0.0050000000000000001
L_C24_series n24 n25 8.0000000000000003e-10
C_C24 n25 n8 9.9999999999999995e-07 IC=-23.980597436450537
V_C25 n27 n26 0
R_C25_series n26 n29 0.014999999999999999
L_C25_series n29 n30 8.0000000000000003e-10
C_C25 n30 n28 3.2999999999999998e-08 IC=12.621150055087609
V_C27 n27 n31 0
R_C27_series n31 n32 0.014999999999999999
L_C27_series n32 n33 8.0000000000000003e-10
C_C27 n33 n28 3.2999999999999998e-08 IC=12.621150055087609
V_C30 n27 n34 0
R_C30_series n34 n35 0.014999999999999999
L_C30_series n35 n36 8.0000000000000003e-10
C_C30 n36 n28 3.2999999999999998e-08 IC=12.621150055087609
V_R9 n6 n37 0
R_R9 n37 n38 0.0050000000000000001
V_L3 n38 n39 0
R_L3_series n39 n40 0.029999999999999999
L_L3 n40 n8 5.5999999999999997e-06 IC=0.22826545352309302
V_CA1 n38 n41 0
R_CA1_series n41 n42 0.02
L_CA1_series n42 n43 1.0000000000000001e-09
C_CA1 n43 0 2.1999999999999999e-05 IC=23.987445400056231
V_CA2 n38 n44 0
R_CA2_series n44 n45 0.02
L_CA2_series n45 n46 1.0000000000000001e-09
C_CA2 n46 0 2.1999999999999999e-05 IC=23.987445400056231
V_CA3 n38 n47 0
R_CA3_series n47 n48 0.02
L_CA3_series n48 n49 1.0000000000000001e-09
C_CA3 n49 0 2.1999999999999999e-05 IC=23.987445400056231
V_CA4 n38 n50 0
R_CA4_series n50 n51 0.02
L_CA4_series n51 n52 1.0000000000000001e-09
C_CA4 n52 0 2.1999999999999999e-05 IC=23.987445400056231
V_Q1 n8 n53 0
VG_Q1 n56 n54 PULSE(0 10 9.6504352655078846e-07 2e-08 2e-08 4.4254545454545458e-06 9.090909090909091e-06)
RG_Q1 n56 n55 2
L_Q1_d n53 n57 1.0000000000000001e-09
L_Q1_s n54 n58 5.0000000000000003e-10
.model NM_Q1 VDMOS(VTO=3 KP=17.857142857142858 RDS=10000000000 CGDMIN=5.0000000000000002e-11 CGDMAX=5.0000000000000002e-11 CGS=1.0000000000000001e-09 CJO=5.0000000000000003e-10 TT=2e-08 RB=0.02 IS=9.9999999999999998e-13)
M_Q1 n57 n55 n58 NM_Q1
V_Q2 n8 n59 0
VG_Q2 n61 n28 PULSE(0 10 4.9999999999999998e-08 2e-08 2e-08 4.4254545454545458e-06 9.090909090909091e-06)
RG_Q2 n61 n60 2
L_Q2_d n59 n62 1.0000000000000001e-09
L_Q2_s n28 n63 5.0000000000000003e-10
.model NM_Q2 VDMOS(VTO=3 KP=17.857142857142858 RDS=10000000000 CGDMIN=5.0000000000000002e-11 CGDMAX=5.0000000000000002e-11 CGS=1.0000000000000001e-09 CJO=5.0000000000000003e-10 TT=2e-08 RB=0.02 IS=9.9999999999999998e-13)
M_Q2 n62 n60 n63 NM_Q2
V_Q3 n54 n64 0
VG_Q3 n66 0 PULSE(0 10 5.5104980720053353e-06 2e-08 2e-08 4.4254545454545458e-06 9.090909090909091e-06)
RG_Q3 n66 n65 2
L_Q3_d n64 n67 1.0000000000000001e-09
L_Q3_s 0 n68 5.0000000000000003e-10
.model NM_Q3 VDMOS(VTO=3 KP=17.857142857142858 RDS=10000000000 CGDMIN=5.0000000000000002e-11 CGDMAX=5.0000000000000002e-11 CGS=1.0000000000000001e-09 CJO=5.0000000000000003e-10 TT=2e-08 RB=0.02 IS=9.9999999999999998e-13)
M_Q3 n67 n65 n68 NM_Q3
V_Q4 n28 n69 0
VG_Q4 n71 0 PULSE(0 10 4.5954545454545459e-06 2e-08 2e-08 4.4254545454545458e-06 9.090909090909091e-06)
RG_Q4 n71 n70 2
L_Q4_d n69 n72 1.0000000000000001e-09
L_Q4_s 0 n73 5.0000000000000003e-10
.model NM_Q4 VDMOS(VTO=3 KP=17.857142857142858 RDS=10000000000 CGDMIN=5.0000000000000002e-11 CGDMAX=5.0000000000000002e-11 CGS=1.0000000000000001e-09 CJO=5.0000000000000003e-10 TT=2e-08 RB=0.02 IS=9.9999999999999998e-13)
M_Q4 n72 n70 n73 NM_Q4
V_PRIMARY n27 n74 0
R_PRIMARY n74 n75 0.11
L_PRIMARY n75 n54 2.4000000000000001e-05 IC=0.82528799337527414
C_PRIMARY_self n74 n54 1.7801129975954663e-11 IC=24.527371496052503
R_PRIMARY_core n75 n54 30773.183367301404
V_SECONDARY 0 n77 0
R_SECONDARY n77 n79 0.11
L_SECONDARY n79 n78 2.4000000000000001e-05 IC=-0.63954860567643623
C_SECONDARY_self n77 n78 1.7801129975954663e-11 IC=22.192486541037852
R_SECONDARY_core n79 n78 30773.183367301404
KLINK L_PRIMARY L_SECONDARY 0.40000000000000002
V_CSECONDARY n78 n80 0
R_CSECONDARY_series n80 n82 0.014999999999999999
L_CSECONDARY_series n82 n83 8.0000000000000003e-10
C_CSECONDARY n83 n81 8.7204925535080611e-08 IC=-17.77089417355625
V_LOAD n81 n84 0
R_LOAD n84 0 6.8986142714359806
.ic V(n38)=23.987445400056231
.ic V(n8)=23.980597436450537
.options method=gear maxord=2 reltol=1e-4 abstol=1e-9 vntol=1e-6 chgtol=1e-12 gmin=1e-10 rshunt=1e12
.control
set klu
set num_threads=1
set wr_singlescale
set wr_vecnames
save i(L_PRIMARY) i(L_SECONDARY) i(VG_Q1) i(VG_Q2) i(VG_Q3) i(VG_Q4) i(VSUP) i(V_C19) i(V_C20) i(V_C21) i(V_C22) i(V_C23) i(V_C24) i(V_C25) i(V_C27) i(V_C30) i(V_CA1) i(V_CA2) i(V_CA3) i(V_CA4) i(V_CSECONDARY) i(V_L3) i(V_LOAD) i(V_LSOURCE) i(V_PRIMARY) i(V_Q1) i(V_Q2) i(V_Q3) i(V_Q4) i(V_R9) i(V_RSOURCE) i(V_SECONDARY) v(n2) v(n27) v(n28) v(n38) v(n4) v(n54) v(n56) v(n6) v(n61) v(n66) v(n71) v(n78) v(n8) v(n81)
tran 3.5511363636363637e-08 0.00047272727272727272 0 3.5511363636363637e-08 uic
let out0=i(VSUP)
let out1=v(n2)
let out2=i(V_RSOURCE)
let out3=v(n2,n4)
let out4=i(V_LSOURCE)
let out5=v(n4,n6)
let out6=i(V_C19)
let out7=v(n8)
let out8=i(V_C20)
let out9=v(n8)
let out10=i(V_C21)
let out11=v(n8)
let out12=i(V_C22)
let out13=v(n8)
let out14=i(V_C23)
let out15=v(n8)
let out16=i(V_C24)
let out17=v(n8)
let out18=i(V_C25)
let out19=v(n27,n28)
let out20=i(V_C27)
let out21=v(n27,n28)
let out22=i(V_C30)
let out23=v(n27,n28)
let out24=i(V_R9)
let out25=v(n6,n38)
let out26=i(V_L3)
let out27=v(n38,n8)
let out28=i(V_CA1)
let out29=v(n38)
let out30=i(V_CA2)
let out31=v(n38)
let out32=i(V_CA3)
let out33=v(n38)
let out34=i(V_CA4)
let out35=v(n38)
let out36=i(V_Q1)
let out37=v(n8,n54)
let out38=i(VG_Q1)
let out39=v(n56,n54)
let out40=i(V_Q2)
let out41=v(n8,n28)
let out42=i(VG_Q2)
let out43=v(n61,n28)
let out44=i(V_Q3)
let out45=v(n54)
let out46=i(VG_Q3)
let out47=v(n66)
let out48=i(V_Q4)
let out49=v(n28)
let out50=i(VG_Q4)
let out51=v(n71)
let out52=i(V_PRIMARY)
let out53=i(L_PRIMARY)
let out54=v(n27,n54)
let out55=i(V_SECONDARY)
let out56=i(L_SECONDARY)
let out57=v(n78)
let out58=i(V_CSECONDARY)
let out59=v(n78,n81)
let out60=i(V_LOAD)
let out61=v(n81)
let out62=v(n81)
let out63=v(n8)
let out64=v(n38)
let out65=v(n28,n54)
let measure0=-(1*out1)*(1*out0)
meas tran m0 AVG measure0 from=0.00046363636363636361 to=0.00047272727272727272
let measure1=(1*out62)^2/6.8986142714359806
meas tran m1 AVG measure1 from=0.00046363636363636361 to=0.00047272727272727272
let measure2=(1*out53)
meas tran m2 RMS measure2 from=0.00046363636363636361 to=0.00047272727272727272
let measure3=(1*out56)
meas tran m3 RMS measure3 from=0.00046363636363636361 to=0.00047272727272727272
let measure4=abs((1*out53))
meas tran m4 MAX measure4 from=0.00046363636363636361 to=0.00047272727272727272
let measure5=(1*out63)
meas tran m5 PP measure5 from=0.00046363636363636361 to=0.00047272727272727272
let measure6=-(1*out39)*(1*out38)+-(1*out43)*(1*out42)+-(1*out47)*(1*out46)+-(1*out51)*(1*out50)
meas tran m6 AVG measure6 from=0.00046363636363636361 to=0.00047272727272727272
let measure7=(1*out3)*(1*out2)
meas tran m7 AVG measure7 from=0.00046363636363636361 to=0.00047272727272727272
let measure8=(1*out5)*(1*out4)
meas tran m8 AVG measure8 from=0.00046363636363636361 to=0.00047272727272727272
let measure9=(-1*out7)*(1*out6)
meas tran m9 AVG measure9 from=0.00046363636363636361 to=0.00047272727272727272
let measure10=(-1*out9)*(1*out8)
meas tran m10 AVG measure10 from=0.00046363636363636361 to=0.00047272727272727272
let measure11=(-1*out11)*(1*out10)
meas tran m11 AVG measure11 from=0.00046363636363636361 to=0.00047272727272727272
let measure12=(-1*out13)*(1*out12)
meas tran m12 AVG measure12 from=0.00046363636363636361 to=0.00047272727272727272
let measure13=(-1*out15)*(1*out14)
meas tran m13 AVG measure13 from=0.00046363636363636361 to=0.00047272727272727272
let measure14=(-1*out17)*(1*out16)
meas tran m14 AVG measure14 from=0.00046363636363636361 to=0.00047272727272727272
let measure15=(1*out19)*(1*out18)
meas tran m15 AVG measure15 from=0.00046363636363636361 to=0.00047272727272727272
let measure16=(1*out21)*(1*out20)
meas tran m16 AVG measure16 from=0.00046363636363636361 to=0.00047272727272727272
let measure17=(1*out23)*(1*out22)
meas tran m17 AVG measure17 from=0.00046363636363636361 to=0.00047272727272727272
let measure18=(1*out25)*(1*out24)
meas tran m18 AVG measure18 from=0.00046363636363636361 to=0.00047272727272727272
let measure19=(1*out27)*(1*out26)
meas tran m19 AVG measure19 from=0.00046363636363636361 to=0.00047272727272727272
let measure20=(1*out29)*(1*out28)
meas tran m20 AVG measure20 from=0.00046363636363636361 to=0.00047272727272727272
let measure21=(1*out31)*(1*out30)
meas tran m21 AVG measure21 from=0.00046363636363636361 to=0.00047272727272727272
let measure22=(1*out33)*(1*out32)
meas tran m22 AVG measure22 from=0.00046363636363636361 to=0.00047272727272727272
let measure23=(1*out35)*(1*out34)
meas tran m23 AVG measure23 from=0.00046363636363636361 to=0.00047272727272727272
let measure24=(1*out37)*(1*out36)
meas tran m24 AVG measure24 from=0.00046363636363636361 to=0.00047272727272727272
let measure25=(1*out41)*(1*out40)
meas tran m25 AVG measure25 from=0.00046363636363636361 to=0.00047272727272727272
let measure26=(1*out45)*(1*out44)
meas tran m26 AVG measure26 from=0.00046363636363636361 to=0.00047272727272727272
let measure27=(1*out49)*(1*out48)
meas tran m27 AVG measure27 from=0.00046363636363636361 to=0.00047272727272727272
let measure28=(1*out54)*(1*out52)
meas tran m28 AVG measure28 from=0.00046363636363636361 to=0.00047272727272727272
let measure29=(-1*out57)*(1*out55)
meas tran m29 AVG measure29 from=0.00046363636363636361 to=0.00047272727272727272
let measure30=(1*out59)*(1*out58)
meas tran m30 AVG measure30 from=0.00046363636363636361 to=0.00047272727272727272
let measure31=(1*out61)*(1*out60)
meas tran m31 AVG measure31 from=0.00046363636363636361 to=0.00047272727272727272
linearize out0 out1 out2 out3 out4 out5 out6 out7 out8 out9 out10 out11 out12 out13 out14 out15 out16 out17 out18 out19 out20 out21 out22 out23 out24 out25 out26 out27 out28 out29 out30 out31 out32 out33 out34 out35 out36 out37 out38 out39 out40 out41 out42 out43 out44 out45 out46 out47 out48 out49 out50 out51 out52 out53 out54 out55 out56 out57 out58 out59 out60 out61 out62 out63 out64 out65
wrdata transient.dat out0 out1 out2 out3 out4 out5 out6 out7 out8 out9 out10 out11 out12 out13 out14 out15 out16 out17 out18 out19 out20 out21 out22 out23 out24 out25 out26 out27 out28 out29 out30 out31 out32 out33 out34 out35 out36 out37 out38 out39 out40 out41 out42 out43 out44 out45 out46 out47 out48 out49 out50 out51 out52 out53 out54 out55 out56 out57 out58 out59 out60 out61 out62 out63 out64 out65
rusage all
quit
.endc
.end
