Transient power circuit
FMODE0_0 0 n2 V_PCB0 -3.1263888203177764e-05
FMODE0_3 0 n2 V_PCB3 0.0027254813251565433
FMODE0_5 0 n2 V_PCB5 -0.0037726233254458934
FMODE0_7 0 n2 V_PCB7 0.0022343453738755295
FMODE0_9 0 n2 V_PCB9 -0.00041283436754460602
FMODE0_21 0 n2 V_PCB21 -1.0911943257809477e-05
FMODE0_23 0 n2 V_PCB23 -1.2081379347035953e-05
RMODE0 n2 0 1
FMODE1_0 0 n3 V_PCB0 0.0001241290762937217
FMODE1_3 0 n3 V_PCB3 -0.0044865684684934478
FMODE1_5 0 n3 V_PCB5 -0.00041974718520652367
FMODE1_7 0 n3 V_PCB7 0.0044597809480207235
FMODE1_9 0 n3 V_PCB9 -0.0016562916445198249
FMODE1_21 0 n3 V_PCB21 1.7486206407927244e-05
FMODE1_23 0 n3 V_PCB23 -9.6906176342760771e-06
RMODE1 n3 0 1
FMODE2_1 0 n4 V_PCB1 -0.00050310533920583638
FMODE2_2 0 n4 V_PCB2 0.0023532983049662673
FMODE2_4 0 n4 V_PCB4 -0.0040415356638089745
FMODE2_6 0 n4 V_PCB6 0.0040240992368930839
FMODE2_8 0 n4 V_PCB8 -0.0023134874725188395
FMODE2_10 0 n4 V_PCB10 0.00047160900338077478
FMODE2_18 0 n4 V_PCB18 -6.3255074473726912e-05
FMODE2_19 0 n4 V_PCB19 5.9395933083366191e-05
RMODE2 n4 0 1
FMODE3_1 0 n5 V_PCB1 0.001488632453948512
FMODE3_2 0 n5 V_PCB2 -0.0044779414335806523
FMODE3_4 0 n5 V_PCB4 0.0026580770551968644
FMODE3_6 0 n5 V_PCB6 0.0027664287441775642
FMODE3_8 0 n5 V_PCB8 -0.0044390048776590174
FMODE3_10 0 n5 V_PCB10 0.0013408018974613051
FMODE3_18 0 n5 V_PCB18 0.00041969313831575908
FMODE3_19 0 n5 V_PCB19 0.00036756115320717798
RMODE3 n5 0 1
FMODE4_11 0 n6 V_PCB11 0.0029203109458699845
FMODE4_13 0 n6 V_PCB13 -0.0063921696331877432
FMODE4_15 0 n6 V_PCB15 0.0046993685845590624
RMODE4 n6 0 1
FMODE5_12 0 n7 V_PCB12 -0.003266185653719075
FMODE5_14 0 n7 V_PCB14 0.0073326308161101974
FMODE5_16 0 n7 V_PCB16 -0.0036355026013978591
FMODE5_22 0 n7 V_PCB22 -0.00048561431381850573
RMODE5 n7 0 1
FMODE6_1 0 n8 V_PCB1 0.0026170686851077394
FMODE6_2 0 n8 V_PCB2 -0.00436151563377321
FMODE6_4 0 n8 V_PCB4 -0.0031208547530989484
FMODE6_6 0 n8 V_PCB6 0.0026817304083229443
FMODE6_8 0 n8 V_PCB8 0.0045196727533137748
FMODE6_10 0 n8 V_PCB10 -0.0021419056138338726
FMODE6_18 0 n8 V_PCB18 0.003203029714790322
FMODE6_19 0 n8 V_PCB19 -0.0026101172515261774
RMODE6 n8 0 1
FMODE7_0 0 n9 V_PCB0 -0.00125778224106493
FMODE7_3 0 n9 V_PCB3 0.0042367325489521363
FMODE7_5 0 n9 V_PCB5 0.0052044480040197537
FMODE7_7 0 n9 V_PCB7 0.0024250500575711395
FMODE7_9 0 n9 V_PCB9 -0.0063609752728004841
FMODE7_21 0 n9 V_PCB21 -0.00017482095550549093
FMODE7_23 0 n9 V_PCB23 -0.00013467942335999015
RMODE7 n9 0 1
FMODE8_1 0 n10 V_PCB1 0.0038393093338165841
FMODE8_2 0 n10 V_PCB2 -0.00045208379635602473
FMODE8_4 0 n10 V_PCB4 0.00057356243898302247
FMODE8_6 0 n10 V_PCB6 0.0027809965489992081
FMODE8_8 0 n10 V_PCB8 0.0021753070631927254
FMODE8_10 0 n10 V_PCB10 -0.0032756227768154541
FMODE8_18 0 n10 V_PCB18 -0.0089266387562395334
FMODE8_19 0 n10 V_PCB19 0.0022768503628356456
RMODE8 n10 0 1
FMODE9_0 0 n11 V_PCB0 0.011218992706957202
FMODE9_3 0 n11 V_PCB3 0.0006210021870678798
FMODE9_5 0 n11 V_PCB5 0.00039597137629887607
FMODE9_7 0 n11 V_PCB7 -0.00022116089195756226
FMODE9_9 0 n11 V_PCB9 -0.0015437795627481865
FMODE9_21 0 n11 V_PCB21 -0.0006852920282801613
FMODE9_23 0 n11 V_PCB23 -0.00011728868745521581
RMODE9 n11 0 1
FMODE10_1 0 n12 V_PCB1 -0.0042719580502988234
FMODE10_2 0 n12 V_PCB2 0.0016198492910160665
FMODE10_4 0 n12 V_PCB4 0.0047471258044043934
FMODE10_6 0 n12 V_PCB6 0.0043213923721710382
FMODE10_8 0 n12 V_PCB8 0.0017176342354977875
FMODE10_10 0 n12 V_PCB10 0.00033047044751104143
FMODE10_18 0 n12 V_PCB18 -0.0020080530532992783
FMODE10_19 0 n12 V_PCB19 -0.0079873162337580714
RMODE10 n12 0 1
FMODE11_17 0 n13 V_PCB17 -0.0081339732062566446
FMODE11_20 0 n13 V_PCB20 0.0087944471069398306
RMODE11 n13 0 1
FMODE12_11 0 n14 V_PCB11 -0.007144120130209511
FMODE12_13 0 n14 V_PCB13 0.0033765896258442763
FMODE12_15 0 n14 V_PCB15 0.0090324444914554689
RMODE12 n14 0 1
FMODE13_12 0 n15 V_PCB12 -0.0026454015910869389
FMODE13_14 0 n15 V_PCB14 0.0016319806675474376
FMODE13_16 0 n15 V_PCB16 0.0070188519201702555
FMODE13_22 0 n15 V_PCB22 -0.010110842731773857
RMODE13 n15 0 1
FMODE14_1 0 n16 V_PCB1 -0.0072771042911047154
FMODE14_2 0 n16 V_PCB2 -0.0012712222600675307
FMODE14_4 0 n16 V_PCB4 0.00219485298518111
FMODE14_6 0 n16 V_PCB6 0.0032193297129322878
FMODE14_8 0 n16 V_PCB8 0.00058250095163253938
FMODE14_10 0 n16 V_PCB10 -0.0076236331523425087
FMODE14_18 0 n16 V_PCB18 0.0025122876636326026
FMODE14_19 0 n16 V_PCB19 0.0058587710470340611
RMODE14 n16 0 1
FMODE15_0 0 n17 V_PCB0 -0.00055270837243158151
FMODE15_3 0 n17 V_PCB3 -0.00027577611670097314
FMODE15_5 0 n17 V_PCB5 -0.00039536487091820831
FMODE15_7 0 n17 V_PCB7 -0.00042476628335577995
FMODE15_9 0 n17 V_PCB9 -0.00050505462750670622
FMODE15_21 0 n17 V_PCB21 -0.010039831570937076
FMODE15_23 0 n17 V_PCB23 0.010446099504259607
RMODE15 n17 0 1
FMODE16_12 0 n18 V_PCB12 -0.010710086502184361
FMODE16_14 0 n18 V_PCB14 -0.00028165560741671774
FMODE16_16 0 n18 V_PCB16 0.0079487130200660266
FMODE16_22 0 n18 V_PCB22 0.0082746478439628141
RMODE16 n18 0 1
FMODE17_0 0 n19 V_PCB0 0.00077578187615862841
FMODE17_3 0 n19 V_PCB3 0.0037098477463128427
FMODE17_5 0 n19 V_PCB5 0.0065228220594619069
FMODE17_7 0 n19 V_PCB7 0.0085054856564015582
FMODE17_9 0 n19 V_PCB9 0.011214938476458032
FMODE17_21 0 n19 V_PCB21 -0.0072100117759436883
FMODE17_23 0 n19 V_PCB23 -0.005655655537359929
RMODE17 n19 0 1
FMODE18_1 0 n20 V_PCB1 -0.0097749441295460985
FMODE18_2 0 n20 V_PCB2 -0.0084746844150004295
FMODE18_4 0 n20 V_PCB4 -0.0053125984246029266
FMODE18_6 0 n20 V_PCB6 -0.00023651541348260796
FMODE18_8 0 n20 V_PCB8 0.0046377988497402706
FMODE18_10 0 n20 V_PCB10 0.009917688432541585
FMODE18_18 0 n20 V_PCB18 -0.0059043390628725273
FMODE18_19 0 n20 V_PCB19 0.0031160105749394409
RMODE18 n20 0 1
FMODE19_0 0 n21 V_PCB0 -0.0022396856919096901
FMODE19_3 0 n21 V_PCB3 -0.0037935426488511946
FMODE19_5 0 n21 V_PCB5 -0.0061875152326659232
FMODE19_7 0 n21 V_PCB7 -0.0077403219707197048
FMODE19_9 0 n21 V_PCB9 -0.0092439080546027098
FMODE19_21 0 n21 V_PCB21 -0.017302885029456341
FMODE19_23 0 n21 V_PCB23 -0.017844454315293877
RMODE19 n21 0 1
FMODE20_11 0 n22 V_PCB11 0.023369386662932742
FMODE20_13 0 n22 V_PCB13 0.019034151432913558
FMODE20_15 0 n22 V_PCB15 0.011368261108199326
RMODE20 n22 0 1
FMODE21_17 0 n23 V_PCB17 -0.03101942719782266
FMODE21_20 0 n23 V_PCB20 -0.028689829688260393
RMODE21 n23 0 1
FMODE22_12 0 n24 V_PCB12 0.02907277682204782
FMODE22_14 0 n24 V_PCB14 0.026436425537246906
FMODE22_16 0 n24 V_PCB16 0.025301538915791153
FMODE22_22 0 n24 V_PCB22 0.014224563090461037
RMODE22 n24 0 1
FMODE23_1 0 n25 V_PCB1 0.010673595595895593
FMODE23_2 0 n25 V_PCB2 0.014912249812935024
FMODE23_4 0 n25 V_PCB4 0.017988656065052941
FMODE23_6 0 n25 V_PCB6 0.020743987600289306
FMODE23_8 0 n25 V_PCB8 0.022607444046756454
FMODE23_10 0 n25 V_PCB10 0.024131523898767809
FMODE23_18 0 n25 V_PCB18 0.013633234282548392
FMODE23_19 0 n25 V_PCB19 0.021662543514646838
RMODE23 n25 0 1
FMODE24_0 0 n26 V_PCB0 2.9236693057056881e-06
FMODE24_1 0 n26 V_PCB1 -1.7041174815402417e-05
FMODE24_2 0 n26 V_PCB2 1.3882650606292043e-05
FMODE24_3 0 n26 V_PCB3 1.2360893261788217e-06
FMODE24_4 0 n26 V_PCB4 1.1638105674335338e-05
FMODE24_5 0 n26 V_PCB5 7.2305429522684819e-06
FMODE24_6 0 n26 V_PCB6 -3.326954993692481e-06
FMODE24_7 0 n26 V_PCB7 7.7353177298950518e-06
FMODE24_8 0 n26 V_PCB8 -1.9378059584432809e-05
FMODE24_9 0 n26 V_PCB9 6.2528422228038907e-06
FMODE24_10 0 n26 V_PCB10 -3.2026980679488348e-05
FMODE24_11 0 n26 V_PCB11 -0.0014773901708698748
FMODE24_12 0 n26 V_PCB12 0.0014623640211907864
FMODE24_13 0 n26 V_PCB13 0.0031291460645184758
FMODE24_14 0 n26 V_PCB14 -0.0029557509060270247
FMODE24_15 0 n26 V_PCB15 -0.0019566843817067593
FMODE24_16 0 n26 V_PCB16 0.0014640785054038253
FMODE24_17 0 n26 V_PCB17 -3.2861031097034823e-07
FMODE24_18 0 n26 V_PCB18 2.7782039156213238e-07
FMODE24_19 0 n26 V_PCB19 4.3423771583215954e-05
FMODE24_20 0 n26 V_PCB20 2.2994565472943039e-06
FMODE24_21 0 n26 V_PCB21 8.9030663662580256e-07
FMODE24_22 0 n26 V_PCB22 3.0008421619377159e-05
FMODE24_23 0 n26 V_PCB23 -1.1265718370523288e-05
LMODE24 n26 0 9.9999999999999995e-07 IC=-9.7541116910648866e-06
FMODE25_0 0 n27 V_PCB0 -5.6787697511598309e-05
FMODE25_1 0 n27 V_PCB1 -1.4300111243647119e-05
FMODE25_2 0 n27 V_PCB2 2.7463505678588641e-05
FMODE25_3 0 n27 V_PCB3 4.7168643490963126e-06
FMODE25_4 0 n27 V_PCB4 6.1067249880398181e-06
FMODE25_5 0 n27 V_PCB5 1.1626681858490304e-05
FMODE25_6 0 n27 V_PCB6 -9.5595091727012496e-06
FMODE25_7 0 n27 V_PCB7 8.0692172809862976e-06
FMODE25_8 0 n27 V_PCB8 -2.2361074784222195e-05
FMODE25_9 0 n27 V_PCB9 -4.7576937825267626e-05
FMODE25_10 0 n27 V_PCB10 -4.7716138675895245e-05
FMODE25_11 0 n27 V_PCB11 0.001392252369015504
FMODE25_12 0 n27 V_PCB12 0.0016944612416009768
FMODE25_13 0 n27 V_PCB13 -0.0029147274260537615
FMODE25_14 0 n27 V_PCB14 -0.0033679522101690835
FMODE25_15 0 n27 V_PCB15 0.0018878747686670596
FMODE25_16 0 n27 V_PCB16 0.00166183109783455
FMODE25_17 0 n27 V_PCB17 1.5049539366584657e-05
FMODE25_18 0 n27 V_PCB18 -1.0510705255795549e-05
FMODE25_19 0 n27 V_PCB19 6.9608990326950194e-05
FMODE25_20 0 n27 V_PCB20 -1.2214521838022101e-05
FMODE25_21 0 n27 V_PCB21 7.3415835261541785e-06
FMODE25_22 0 n27 V_PCB22 1.4589746596349736e-05
FMODE25_23 0 n27 V_PCB23 1.1049228098674127e-05
LMODE25 n27 0 9.9999999999999995e-07 IC=-3.1533565938316239e-06
FMODE26_0 0 n28 V_PCB0 0.0055923184458819171
FMODE26_1 0 n28 V_PCB1 -0.00043380648775858202
FMODE26_2 0 n28 V_PCB2 -0.00038275487249695713
FMODE26_3 0 n28 V_PCB3 -5.1878652940592877e-06
FMODE26_4 0 n28 V_PCB4 4.542658158225832e-05
FMODE26_5 0 n28 V_PCB5 -4.4248355786870723e-05
FMODE26_6 0 n28 V_PCB6 0.00051460547781130876
FMODE26_7 0 n28 V_PCB7 -4.2295898769973959e-05
FMODE26_8 0 n28 V_PCB8 0.00058943690236055372
FMODE26_9 0 n28 V_PCB9 -0.00025828411193481716
FMODE26_10 0 n28 V_PCB10 -0.00038637604562625919
FMODE26_11 0 n28 V_PCB11 2.4345009514542483e-05
FMODE26_12 0 n28 V_PCB12 1.582609212059849e-05
FMODE26_13 0 n28 V_PCB13 -3.3397169627252144e-05
FMODE26_14 0 n28 V_PCB14 -2.9131635157980742e-05
FMODE26_15 0 n28 V_PCB15 1.0924437829091576e-05
FMODE26_16 0 n28 V_PCB16 2.7659892797265436e-05
FMODE26_17 0 n28 V_PCB17 -0.00013173722826408869
FMODE26_18 0 n28 V_PCB18 0.00014230655927092672
FMODE26_19 0 n28 V_PCB19 -0.00010347952046650009
FMODE26_20 0 n28 V_PCB20 0.00010545632764193329
FMODE26_21 0 n28 V_PCB21 -0.00010231174766946633
FMODE26_22 0 n28 V_PCB22 5.5954973348254598e-06
FMODE26_23 0 n28 V_PCB23 -2.3406116692165956e-05
LMODE26 n28 0 9.9999999999999995e-07 IC=-4.5819638976358203e-05
FMODE27_0 0 n29 V_PCB0 -0.00092135350173188247
FMODE27_1 0 n29 V_PCB1 -0.0040639747025745842
FMODE27_2 0 n29 V_PCB2 0.0007540293049389888
FMODE27_3 0 n29 V_PCB3 0.00018355279750863885
FMODE27_4 0 n29 V_PCB4 0.0025385435036612627
FMODE27_5 0 n29 V_PCB5 0.0002927488382598487
FMODE27_6 0 n29 V_PCB6 0.0028442353720935709
FMODE27_7 0 n29 V_PCB7 0.0002787606047494175
FMODE27_8 0 n29 V_PCB8 0.0014698255529856743
FMODE27_9 0 n29 V_PCB9 0.00013321502604985696
FMODE27_10 0 n29 V_PCB10 -0.0034007970487156471
FMODE27_11 0 n29 V_PCB11 4.719536761699934e-05
FMODE27_12 0 n29 V_PCB12 7.5552904779311285e-05
FMODE27_13 0 n29 V_PCB13 -4.1137383926523429e-06
FMODE27_14 0 n29 V_PCB14 6.0678643011024408e-05
FMODE27_15 0 n29 V_PCB15 -5.1614438691247456e-05
FMODE27_16 0 n29 V_PCB16 -7.4986468653974301e-05
FMODE27_17 0 n29 V_PCB17 -3.4532772695527314e-05
FMODE27_18 0 n29 V_PCB18 -0.00055390650110564868
FMODE27_19 0 n29 V_PCB19 -0.00047150011617115491
FMODE27_20 0 n29 V_PCB20 3.3665899134458901e-05
FMODE27_21 0 n29 V_PCB21 -4.1878675397098344e-05
FMODE27_22 0 n29 V_PCB22 -4.8017612804888327e-05
FMODE27_23 0 n29 V_PCB23 5.3609306545773738e-05
LMODE27 n29 0 9.9999999999999995e-07 IC=0.0001143940118916842
FMODE28_0 0 n30 V_PCB0 0.00050886345315548766
FMODE28_1 0 n30 V_PCB1 0.0014343137026607896
FMODE28_2 0 n30 V_PCB2 0.00066641603104004236
FMODE28_3 0 n30 V_PCB3 0.0012356512284862648
FMODE28_4 0 n30 V_PCB4 0.00016916569399025327
FMODE28_5 0 n30 V_PCB5 0.0024069344986944762
FMODE28_6 0 n30 V_PCB6 -0.00032970774547806946
FMODE28_7 0 n30 V_PCB7 0.0033218133060931997
FMODE28_8 0 n30 V_PCB8 -0.00073784351881036334
FMODE28_9 0 n30 V_PCB9 0.0061691525411871548
FMODE28_10 0 n30 V_PCB10 -0.0014906679468257036
FMODE28_11 0 n30 V_PCB11 -0.00026208450347779368
FMODE28_12 0 n30 V_PCB12 -0.00047897555909733172
FMODE28_13 0 n30 V_PCB13 2.2681404107211532e-05
FMODE28_14 0 n30 V_PCB14 -5.3024571721851677e-05
FMODE28_15 0 n30 V_PCB15 0.00031400619748376738
FMODE28_16 0 n30 V_PCB16 0.00034360582013281634
FMODE28_17 0 n30 V_PCB17 -0.00022760790334006321
FMODE28_18 0 n30 V_PCB18 -0.00046256202241394718
FMODE28_19 0 n30 V_PCB19 0.0010620232634996286
FMODE28_20 0 n30 V_PCB20 0.0001850481222965636
FMODE28_21 0 n30 V_PCB21 -0.00012830999028768894
FMODE28_22 0 n30 V_PCB22 0.00035939202166654122
FMODE28_23 0 n30 V_PCB23 -0.00045424092245335232
LMODE28 n30 0 9.9999999999999995e-07 IC=-0.00021980571849109765
FMODE29_0 0 n31 V_PCB0 9.7943203877975572e-07
FMODE29_1 0 n31 V_PCB1 -0.00010728815707485224
FMODE29_2 0 n31 V_PCB2 -2.1799017438856991e-05
FMODE29_3 0 n31 V_PCB3 -1.3549913664558936e-05
FMODE29_4 0 n31 V_PCB4 1.9787811216744453e-05
FMODE29_5 0 n31 V_PCB5 -3.0993043695684786e-05
FMODE29_6 0 n31 V_PCB6 4.2313058016993553e-05
FMODE29_7 0 n31 V_PCB7 -5.5164561705611747e-05
FMODE29_8 0 n31 V_PCB8 5.2856538995528707e-05
FMODE29_9 0 n31 V_PCB9 -9.9620241717097305e-05
FMODE29_10 0 n31 V_PCB10 0.0001329160180778221
FMODE29_11 0 n31 V_PCB11 -0.0048508955181598206
FMODE29_12 0 n31 V_PCB12 0.0019688008677565929
FMODE29_13 0 n31 V_PCB13 0.0013466950007458695
FMODE29_14 0 n31 V_PCB14 -5.5758976113127207e-05
FMODE29_15 0 n31 V_PCB15 0.005728524983473233
FMODE29_16 0 n31 V_PCB16 -0.0021950154513151665
FMODE29_17 0 n31 V_PCB17 -1.9432333089336704e-05
FMODE29_18 0 n31 V_PCB18 5.901181532987025e-05
FMODE29_19 0 n31 V_PCB19 -0.00019852487290945107
FMODE29_20 0 n31 V_PCB20 1.6199603448515551e-05
FMODE29_21 0 n31 V_PCB21 -1.408548621584393e-05
FMODE29_22 0 n31 V_PCB22 0.0003970499662255642
FMODE29_23 0 n31 V_PCB23 3.3880665133994019e-05
LMODE29 n31 0 9.9999999999999995e-07 IC=-3.0750892472672745e-05
FMODE30_0 0 n32 V_PCB0 0.00043553222900416121
FMODE30_1 0 n32 V_PCB1 0.00271782004676054
FMODE30_2 0 n32 V_PCB2 0.0013669005982087843
FMODE30_3 0 n32 V_PCB3 -0.00019838569464663018
FMODE30_4 0 n32 V_PCB4 0.00085351090741463305
FMODE30_5 0 n32 V_PCB5 -0.00039042363429998855
FMODE30_6 0 n32 V_PCB6 0.00030441258830548766
FMODE30_7 0 n32 V_PCB7 -0.00054073608176732825
FMODE30_8 0 n32 V_PCB8 -0.00036881536870691936
FMODE30_9 0 n32 V_PCB9 -0.0011126072670906977
FMODE30_10 0 n32 V_PCB10 -0.0021205686125472258
FMODE30_11 0 n32 V_PCB11 1.4623277239099362e-05
FMODE30_12 0 n32 V_PCB12 0.00033658579949808712
FMODE30_13 0 n32 V_PCB13 1.8956104885071287e-05
FMODE30_14 0 n32 V_PCB14 7.0136592723962231e-05
FMODE30_15 0 n32 V_PCB15 -5.4036927096788244e-05
FMODE30_16 0 n32 V_PCB16 -0.00036409124942690462
FMODE30_17 0 n32 V_PCB17 0.0043716903646434744
FMODE30_18 0 n32 V_PCB18 -0.0039564134097410612
FMODE30_19 0 n32 V_PCB19 0.0015855790386249873
FMODE30_20 0 n32 V_PCB20 -0.0043167892383477778
FMODE30_21 0 n32 V_PCB21 0.00092023982555583257
FMODE30_22 0 n32 V_PCB22 0.00012639797891922036
FMODE30_23 0 n32 V_PCB23 3.1467502882147301e-07
LMODE30 n32 0 9.9999999999999995e-07 IC=0.0013333573845011586
FMODE31_0 0 n33 V_PCB0 7.794817520210042e-05
FMODE31_1 0 n33 V_PCB1 0.0016441433581424025
FMODE31_2 0 n33 V_PCB2 0.00080655108245747398
FMODE31_3 0 n33 V_PCB3 -9.6774484437408203e-05
FMODE31_4 0 n33 V_PCB4 0.00030875773751538958
FMODE31_5 0 n33 V_PCB5 -0.00019310556623951871
FMODE31_6 0 n33 V_PCB6 -0.00024945857406800595
FMODE31_7 0 n33 V_PCB7 -0.00025914984016785019
FMODE31_8 0 n33 V_PCB8 -0.00078407466676727383
FMODE31_9 0 n33 V_PCB9 -0.00047551889627859087
FMODE31_10 0 n33 V_PCB10 -0.0019355701783788529
FMODE31_11 0 n33 V_PCB11 0.0015921859071580703
FMODE31_12 0 n33 V_PCB12 0.0048839743392632539
FMODE31_13 0 n33 V_PCB13 -0.00056992502934583673
FMODE31_14 0 n33 V_PCB14 -9.0749498501917556e-05
FMODE31_15 0 n33 V_PCB15 -0.0021325089844871905
FMODE31_16 0 n33 V_PCB16 -0.005189646021647825
FMODE31_17 0 n33 V_PCB17 -0.0022705665970642434
FMODE31_18 0 n33 V_PCB18 -0.00082500901378501081
FMODE31_19 0 n33 V_PCB19 0.0014761936208995379
FMODE31_20 0 n33 V_PCB20 0.0023465395854681205
FMODE31_21 0 n33 V_PCB21 -0.00029290284275751161
FMODE31_22 0 n33 V_PCB22 0.0009155606398032161
FMODE31_23 0 n33 V_PCB23 0.0004500001108347635
LMODE31 n33 0 9.9999999999999995e-07 IC=-0.00067792948643229448
FMODE32_0 0 n34 V_PCB0 -2.283572885373068e-05
FMODE32_1 0 n34 V_PCB1 -0.0025827219353966313
FMODE32_2 0 n34 V_PCB2 -0.0012939992533281242
FMODE32_3 0 n34 V_PCB3 0.00036114838874788452
FMODE32_4 0 n34 V_PCB4 -0.00063967329829240423
FMODE32_5 0 n34 V_PCB5 0.00074524211896248712
FMODE32_6 0 n34 V_PCB6 0.0001305428048331769
FMODE32_7 0 n34 V_PCB7 0.0010649023733131039
FMODE32_8 0 n34 V_PCB8 0.00098616017836882734
FMODE32_9 0 n34 V_PCB9 0.0020552385422378406
FMODE32_10 0 n34 V_PCB10 0.0031992759936543378
FMODE32_11 0 n34 V_PCB11 0.0010505743138716761
FMODE32_12 0 n34 V_PCB12 0.0028269476054528313
FMODE32_13 0 n34 V_PCB13 -0.00041074877202252198
FMODE32_14 0 n34 V_PCB14 -0.00022788980628048503
FMODE32_15 0 n34 V_PCB15 -0.0014188678731391622
FMODE32_16 0 n34 V_PCB16 -0.0031210432415622719
FMODE32_17 0 n34 V_PCB17 0.0033912840926171774
FMODE32_18 0 n34 V_PCB18 0.0022390372816425063
FMODE32_19 0 n34 V_PCB19 -0.0026308984756347686
FMODE32_20 0 n34 V_PCB20 -0.0035882133695889634
FMODE32_21 0 n34 V_PCB21 0.00014292038656204081
FMODE32_22 0 n34 V_PCB22 0.00082726070391387035
FMODE32_23 0 n34 V_PCB23 0.00021778741469197284
LMODE32 n34 0 9.9999999999999995e-07 IC=0.00077669858319637263
FMODE33_0 0 n35 V_PCB0 0.00013979528985854481
FMODE33_1 0 n35 V_PCB1 0.0022549707577297585
FMODE33_2 0 n35 V_PCB2 0.0016421180380749264
FMODE33_3 0 n35 V_PCB3 0.00014133290653148243
FMODE33_4 0 n35 V_PCB4 0.0016416898247539476
FMODE33_5 0 n35 V_PCB5 0.00028148083669513681
FMODE33_6 0 n35 V_PCB6 0.0016917065122439836
FMODE33_7 0 n35 V_PCB7 0.00039883308060325158
FMODE33_8 0 n35 V_PCB8 0.0017250684434252841
FMODE33_9 0 n35 V_PCB9 0.00073024079689655292
FMODE33_10 0 n35 V_PCB10 0.0029473071632608022
FMODE33_11 0 n35 V_PCB11 0.00011261989953672558
FMODE33_12 0 n35 V_PCB12 0.00025021511724784352
FMODE33_13 0 n35 V_PCB13 -4.5944435041410386e-05
FMODE33_14 0 n35 V_PCB14 -6.9063983321611337e-05
FMODE33_15 0 n35 V_PCB15 -0.00012411196656817312
FMODE33_16 0 n35 V_PCB16 -3.3305780743888743e-05
FMODE33_17 0 n35 V_PCB17 -0.0013180884214066418
FMODE33_18 0 n35 V_PCB18 -0.0052509207041411673
FMODE33_19 0 n35 V_PCB19 -0.0065908247228782741
FMODE33_20 0 n35 V_PCB20 0.0016572193787533292
FMODE33_21 0 n35 V_PCB21 0.00039545962006147398
FMODE33_22 0 n35 V_PCB22 -0.0013419201100467494
FMODE33_23 0 n35 V_PCB23 0.00097127378379953996
LMODE33 n35 0 9.9999999999999995e-07 IC=0.0013020434187877702
FMODE34_0 0 n36 V_PCB0 -0.00015938013576681043
FMODE34_1 0 n36 V_PCB1 -0.0020234187838958145
FMODE34_2 0 n36 V_PCB2 -0.0016914589452949797
FMODE34_3 0 n36 V_PCB3 -1.3100770233867264e-06
FMODE34_4 0 n36 V_PCB4 -0.00081846451551672423
FMODE34_5 0 n36 V_PCB5 9.6114685360731002e-06
FMODE34_6 0 n36 V_PCB6 0.00044238873122838475
FMODE34_7 0 n36 V_PCB7 2.1504268186472795e-05
FMODE34_8 0 n36 V_PCB8 0.0014995353622436214
FMODE34_9 0 n36 V_PCB9 2.7165711786328078e-05
FMODE34_10 0 n36 V_PCB10 0.002706648525695788
FMODE34_11 0 n36 V_PCB11 6.2221602253770942e-05
FMODE34_12 0 n36 V_PCB12 -0.0017881676286159668
FMODE34_13 0 n36 V_PCB13 -5.3222214038784289e-05
FMODE34_14 0 n36 V_PCB14 -0.0010444191085828157
FMODE34_15 0 n36 V_PCB15 -7.3257959907605137e-05
FMODE34_16 0 n36 V_PCB16 -0.00042181337736530523
FMODE34_17 0 n36 V_PCB17 -0.00071350334940878076
FMODE34_18 0 n36 V_PCB18 -0.0043705108122868361
FMODE34_19 0 n36 V_PCB19 0.0022662836438904197
FMODE34_20 0 n36 V_PCB20 0.00098231067145543955
FMODE34_21 0 n36 V_PCB21 0.00075775488350634341
FMODE34_22 0 n36 V_PCB22 0.0085313361483195412
FMODE34_23 0 n36 V_PCB23 -0.0017777295639038381
LMODE34 n36 0 9.9999999999999995e-07 IC=-0.0010284540838308787
FMODE35_0 0 n37 V_PCB0 0.00012644944945910684
FMODE35_1 0 n37 V_PCB1 0.0034895206312777162
FMODE35_2 0 n37 V_PCB2 0.002933617138923168
FMODE35_3 0 n37 V_PCB3 -0.0001342843148688771
FMODE35_4 0 n37 V_PCB4 0.0017751561371409355
FMODE35_5 0 n37 V_PCB5 -0.00030571703736325257
FMODE35_6 0 n37 V_PCB6 2.5612797683000075e-05
FMODE35_7 0 n37 V_PCB7 -0.00045902689327898574
FMODE35_8 0 n37 V_PCB8 -0.0015140793848558059
FMODE35_9 0 n37 V_PCB9 -0.00098205994436477147
FMODE35_10 0 n37 V_PCB10 -0.0032164079758079884
FMODE35_11 0 n37 V_PCB11 4.7377738796079385e-05
FMODE35_12 0 n37 V_PCB12 -0.0017098849122742534
FMODE35_13 0 n37 V_PCB13 4.8385242543299984e-05
FMODE35_14 0 n37 V_PCB14 -0.00081792432365190393
FMODE35_15 0 n37 V_PCB15 8.9670837651045898e-05
FMODE35_16 0 n37 V_PCB16 5.8713730506151221e-05
FMODE35_17 0 n37 V_PCB17 0.0003661250731057385
FMODE35_18 0 n37 V_PCB18 0.0049866212705391598
FMODE35_19 0 n37 V_PCB19 -0.0051949403721225683
FMODE35_20 0 n37 V_PCB20 -0.00057490898332056306
FMODE35_21 0 n37 V_PCB21 -0.00023138041161469274
FMODE35_22 0 n37 V_PCB22 0.0064597047223569999
FMODE35_23 0 n37 V_PCB23 -4.3773456020440162e-05
LMODE35 n37 0 9.9999999999999995e-07 IC=-0.00062829488769226263
FMODE36_0 0 n38 V_PCB0 7.8110841257904981e-05
FMODE36_1 0 n38 V_PCB1 0.00035249446475107282
FMODE36_2 0 n38 V_PCB2 0.00046358236864852255
FMODE36_3 0 n38 V_PCB3 -2.0838995847451484e-05
FMODE36_4 0 n38 V_PCB4 0.00038485232361118297
FMODE36_5 0 n38 V_PCB5 -4.7232071230703645e-05
FMODE36_6 0 n38 V_PCB6 0.00019420736910544261
FMODE36_7 0 n38 V_PCB7 -7.679369678693854e-05
FMODE36_8 0 n38 V_PCB8 1.0564177851990501e-05
FMODE36_9 0 n38 V_PCB9 -0.00022648343287609281
FMODE36_10 0 n38 V_PCB10 -0.00019379637729735974
FMODE36_11 0 n38 V_PCB11 -6.7628877666550178e-05
FMODE36_12 0 n38 V_PCB12 0.00086674701314311264
FMODE36_13 0 n38 V_PCB13 -0.00024658485071065079
FMODE36_14 0 n38 V_PCB14 0.00019859036394646295
FMODE36_15 0 n38 V_PCB15 -0.00029941658640811043
FMODE36_16 0 n38 V_PCB16 -0.00043303674794456591
FMODE36_17 0 n38 V_PCB17 -0.00018035387892875168
FMODE36_18 0 n38 V_PCB18 0.0013065713889938377
FMODE36_19 0 n38 V_PCB19 -0.00096522425621086902
FMODE36_20 0 n38 V_PCB20 0.0010810470081615375
FMODE36_21 0 n38 V_PCB21 0.0099665470703997946
FMODE36_22 0 n38 V_PCB22 -0.0017708568775368712
FMODE36_23 0 n38 V_PCB23 -0.010160397338077803
LMODE36 n38 0 9.9999999999999995e-07 IC=-2.8955654078194597e-06
FMODE37_0 0 n39 V_PCB0 -6.5545279568493135e-05
FMODE37_1 0 n39 V_PCB1 0.00016023667569583941
FMODE37_2 0 n39 V_PCB2 7.6875829229639637e-05
FMODE37_3 0 n39 V_PCB3 -3.9021029290498674e-05
FMODE37_4 0 n39 V_PCB4 5.9787647690355439e-05
FMODE37_5 0 n39 V_PCB5 -9.4806615659338343e-05
FMODE37_6 0 n39 V_PCB6 1.9276922530003377e-05
FMODE37_7 0 n39 V_PCB7 -0.00015403861800952792
FMODE37_8 0 n39 V_PCB8 -3.6317889983941996e-05
FMODE37_9 0 n39 V_PCB9 -0.0003013854621770077
FMODE37_10 0 n39 V_PCB10 -0.00011669766983648588
FMODE37_11 0 n39 V_PCB11 -0.016748140119407597
FMODE37_12 0 n39 V_PCB12 -0.00044291469911283342
FMODE37_13 0 n39 V_PCB13 -0.01462791850750716
FMODE37_14 0 n39 V_PCB14 -0.00028124671450534126
FMODE37_15 0 n39 V_PCB15 -0.010495443742662657
FMODE37_16 0 n39 V_PCB16 0.00021317960234366984
FMODE37_17 0 n39 V_PCB17 -0.00024114045946696644
FMODE37_18 0 n39 V_PCB18 -0.00029500102788377187
FMODE37_19 0 n39 V_PCB19 -0.00039268031420719543
FMODE37_20 0 n39 V_PCB20 -0.00058467643703120149
FMODE37_21 0 n39 V_PCB21 -0.0033323766639677503
FMODE37_22 0 n39 V_PCB22 -0.000305004084838522
FMODE37_23 0 n39 V_PCB23 -0.0025290018925138115
LMODE37 n39 0 9.9999999999999995e-07 IC=-0.00050901984416993847
FMODE38_0 0 n40 V_PCB0 0.00037997743702521358
FMODE38_1 0 n40 V_PCB1 -0.00044115768328672041
FMODE38_2 0 n40 V_PCB2 0.00017159938553922211
FMODE38_3 0 n40 V_PCB3 0.00020264488025404344
FMODE38_4 0 n40 V_PCB4 0.0003127566298799116
FMODE38_5 0 n40 V_PCB5 0.00037939686045460253
FMODE38_6 0 n40 V_PCB6 0.00043350218405461779
FMODE38_7 0 n40 V_PCB7 0.00052794238046273369
FMODE38_8 0 n40 V_PCB8 0.00058552420206043601
FMODE38_9 0 n40 V_PCB9 0.0010864074811087372
FMODE38_10 0 n40 V_PCB10 0.00064468079520421087
FMODE38_11 0 n40 V_PCB11 -0.0036806823624050333
FMODE38_12 0 n40 V_PCB12 0.0013128115014877794
FMODE38_13 0 n40 V_PCB13 -0.002886642574830971
FMODE38_14 0 n40 V_PCB14 0.0022062480953280467
FMODE38_15 0 n40 V_PCB15 -0.0019055885381396365
FMODE38_16 0 n40 V_PCB16 0.0030392504059925389
FMODE38_17 0 n40 V_PCB17 0.0055452945779808551
FMODE38_18 0 n40 V_PCB18 0.0026414704835316621
FMODE38_19 0 n40 V_PCB19 0.0028444462442432888
FMODE38_20 0 n40 V_PCB20 0.0075055445102941423
FMODE38_21 0 n40 V_PCB21 0.019464959179247506
FMODE38_22 0 n40 V_PCB22 0.0028542369465231325
FMODE38_23 0 n40 V_PCB23 0.01951552068161997
LMODE38 n40 0 9.9999999999999995e-07 IC=0.0032261261775870884
FMODE39_0 0 n41 V_PCB0 7.5429122873271845e-05
FMODE39_1 0 n41 V_PCB1 0.00052765172110127642
FMODE39_2 0 n41 V_PCB2 0.0008243688119414852
FMODE39_3 0 n41 V_PCB3 7.2466217991121313e-06
FMODE39_4 0 n41 V_PCB4 0.0009123589847341518
FMODE39_5 0 n41 V_PCB5 2.316363960972856e-06
FMODE39_6 0 n41 V_PCB6 0.00098168748005804753
FMODE39_7 0 n41 V_PCB7 -1.3743994819158105e-05
FMODE39_8 0 n41 V_PCB8 0.00099691563710521246
FMODE39_9 0 n41 V_PCB9 -0.00010696747056613361
FMODE39_10 0 n41 V_PCB10 0.00066122124014467143
FMODE39_11 0 n41 V_PCB11 -0.00013251793664726243
FMODE39_12 0 n41 V_PCB12 -0.021456826860686767
FMODE39_13 0 n41 V_PCB13 -0.00023354043782809755
FMODE39_14 0 n41 V_PCB14 -0.020915648322367846
FMODE39_15 0 n41 V_PCB15 -0.0002193154253108835
FMODE39_16 0 n41 V_PCB16 -0.020586372414634718
FMODE39_17 0 n41 V_PCB17 0.0014260529490881216
FMODE39_18 0 n41 V_PCB18 0.0013983507781049514
FMODE39_19 0 n41 V_PCB19 0.0021593347355681023
FMODE39_20 0 n41 V_PCB20 0.0015987673775823246
FMODE39_21 0 n41 V_PCB21 0.0031563410428789478
FMODE39_22 0 n41 V_PCB22 -0.0076506854790916934
FMODE39_23 0 n41 V_PCB23 0.0033009399278994627
LMODE39 n41 0 9.9999999999999995e-07 IC=0.0011673378645631343
FMODE40_0 0 n42 V_PCB0 -0.00032629168477091227
FMODE40_1 0 n42 V_PCB1 0.01006045348770983
FMODE40_2 0 n42 V_PCB2 0.012450914828265016
FMODE40_3 0 n42 V_PCB3 6.3796421065356149e-05
FMODE40_4 0 n42 V_PCB4 0.013405812095463598
FMODE40_5 0 n42 V_PCB5 0.0001013995242725579
FMODE40_6 0 n42 V_PCB6 0.014234810010235324
FMODE40_7 0 n42 V_PCB7 0.00013038546782493491
FMODE40_8 0 n42 V_PCB8 0.014781953975340038
FMODE40_9 0 n42 V_PCB9 0.00025795266804167329
FMODE40_10 0 n42 V_PCB10 0.015303257051133551
FMODE40_11 0 n42 V_PCB11 -7.3461938402452498e-05
FMODE40_12 0 n42 V_PCB12 0.0014045718348715049
FMODE40_13 0 n42 V_PCB13 -4.6504199095060331e-05
FMODE40_14 0 n42 V_PCB14 0.0013600029985615305
FMODE40_15 0 n42 V_PCB15 -3.2491222705565162e-05
FMODE40_16 0 n42 V_PCB16 0.0013320747754956867
FMODE40_17 0 n42 V_PCB17 -0.0091681984358986512
FMODE40_18 0 n42 V_PCB18 0.0109481110856177
FMODE40_19 0 n42 V_PCB19 0.015223944394350633
FMODE40_20 0 n42 V_PCB20 -0.0087056190267899534
FMODE40_21 0 n42 V_PCB21 -0.00014840345704944714
FMODE40_22 0 n42 V_PCB22 0.0003837438751699687
FMODE40_23 0 n42 V_PCB23 0.00048845949586583668
LMODE40 n42 0 9.9999999999999995e-07 IC=-0.0030009555956412711
FMODE41_0 0 n43 V_PCB0 -0.00017831976327143298
FMODE41_1 0 n43 V_PCB1 0.0037706867713513761
FMODE41_2 0 n43 V_PCB2 0.0045158550277128104
FMODE41_3 0 n43 V_PCB3 -2.9172306288474646e-05
FMODE41_4 0 n43 V_PCB4 0.0047699729869881509
FMODE41_5 0 n43 V_PCB5 -6.0787135374563765e-05
FMODE41_6 0 n43 V_PCB6 0.0049528178651904019
FMODE41_7 0 n43 V_PCB7 -8.8489760039601445e-05
FMODE41_8 0 n43 V_PCB8 0.0050482924259588093
FMODE41_9 0 n43 V_PCB9 -0.00020610051737706626
FMODE41_10 0 n43 V_PCB10 0.0051627606867259571
FMODE41_11 0 n43 V_PCB11 0.0010455821921422932
FMODE41_12 0 n43 V_PCB12 0.0013895716382358427
FMODE41_13 0 n43 V_PCB13 0.00079101634525569119
FMODE41_14 0 n43 V_PCB14 0.00097730957476846111
FMODE41_15 0 n43 V_PCB15 0.0005034218162229435
FMODE41_16 0 n43 V_PCB16 0.00056551232136003396
FMODE41_17 0 n43 V_PCB17 0.02870146571548347
FMODE41_18 0 n43 V_PCB18 0.0040820734159169253
FMODE41_19 0 n43 V_PCB19 0.0044261217245010849
FMODE41_20 0 n43 V_PCB20 0.026709960551551198
FMODE41_21 0 n43 V_PCB21 -0.011649446596322412
FMODE41_22 0 n43 V_PCB22 -0.00055083555691865058
FMODE41_23 0 n43 V_PCB23 -0.0082985456287702469
LMODE41 n43 0 9.9999999999999995e-07 IC=-0.0029149622295689599
FMODE42_0 0 n44 V_PCB0 0.00016641149648320737
FMODE42_1 0 n44 V_PCB1 0.00075862634912522448
FMODE42_2 0 n44 V_PCB2 0.00038468579436083114
FMODE42_3 0 n44 V_PCB3 -0.00012936015500669088
FMODE42_4 0 n44 V_PCB4 0.00022954256590040407
FMODE42_5 0 n44 V_PCB5 -0.00018367063985388801
FMODE42_6 0 n44 V_PCB6 2.3936840642884041e-05
FMODE42_7 0 n44 V_PCB7 -0.0002173717550779173
FMODE42_8 0 n44 V_PCB8 -0.00016884956908776546
FMODE42_9 0 n44 V_PCB9 -0.00042541155725352652
FMODE42_10 0 n44 V_PCB10 -0.00015562183083984462
FMODE42_11 0 n44 V_PCB11 0.0044106351068154935
FMODE42_12 0 n44 V_PCB12 -4.4337888118587847e-05
FMODE42_13 0 n44 V_PCB13 0.0031207870984452362
FMODE42_14 0 n44 V_PCB14 -0.0010932500972358973
FMODE42_15 0 n44 V_PCB15 0.0016947206150552542
FMODE42_16 0 n44 V_PCB16 -0.0023825015838955742
FMODE42_17 0 n44 V_PCB17 0.0033031361494470701
FMODE42_18 0 n44 V_PCB18 -0.00097239418551334493
FMODE42_19 0 n44 V_PCB19 -0.0017241820765383031
FMODE42_20 0 n44 V_PCB20 0.0019404035540003736
FMODE42_21 0 n44 V_PCB21 -0.0068301406329675865
FMODE42_22 0 n44 V_PCB22 -0.0012693510861642287
FMODE42_23 0 n44 V_PCB23 -0.0079740855233196416
RMODE42 n44 0 1
LMODE42 n44 0 1.5915494309189534e-05 IC=-0.0010658748580374385
FMODE43_0 0 n45 V_PCB0 -0.00091026670974464323
FMODE43_1 0 n45 V_PCB1 0.0016175296306032714
FMODE43_2 0 n45 V_PCB2 0.0027551796512373136
FMODE43_3 0 n45 V_PCB3 0.00097093429356949902
FMODE43_4 0 n45 V_PCB4 0.0038161695080006397
FMODE43_5 0 n45 V_PCB5 0.0020936809502917963
FMODE43_6 0 n45 V_PCB6 0.0050209078562469941
FMODE43_7 0 n45 V_PCB7 0.0031491019218210271
FMODE43_8 0 n45 V_PCB8 0.0060993361986890057
FMODE43_9 0 n45 V_PCB9 0.0041981927396363408
FMODE43_10 0 n45 V_PCB10 0.0073230358617780572
FMODE43_11 0 n45 V_PCB11 -0.00013687282742944035
FMODE43_12 0 n45 V_PCB12 0.0027796946785295976
FMODE43_13 0 n45 V_PCB13 -0.00028495940268306961
FMODE43_14 0 n45 V_PCB14 0.0025895702470137452
FMODE43_15 0 n45 V_PCB15 -0.00031202151085125371
FMODE43_16 0 n45 V_PCB16 0.0023638699555103594
FMODE43_17 0 n45 V_PCB17 0.0048521922998239356
FMODE43_18 0 n45 V_PCB18 0.0024122273815379808
FMODE43_19 0 n45 V_PCB19 0.0058845490922572984
FMODE43_20 0 n45 V_PCB20 0.0046081875533164791
FMODE43_21 0 n45 V_PCB21 -0.0014915461985034455
FMODE43_22 0 n45 V_PCB22 6.0811712934832952e-05
FMODE43_23 0 n45 V_PCB23 0.0012492133175473112
RMODE43 n45 0 1
LMODE43 n45 0 1.5915494309189534e-05 IC=-0.00093992917391499844
FMODE44_0 0 n46 V_PCB0 0.001281725147947665
FMODE44_1 0 n46 V_PCB1 0.00092621184557206584
FMODE44_2 0 n46 V_PCB2 0.001102850591060821
FMODE44_3 0 n46 V_PCB3 -0.001597812745471642
FMODE44_4 0 n46 V_PCB4 0.00093618590103750662
FMODE44_5 0 n46 V_PCB5 -0.0034107666625414201
FMODE44_6 0 n46 V_PCB6 0.00057980714475948999
FMODE44_7 0 n46 V_PCB7 -0.0046429013901875807
FMODE44_8 0 n46 V_PCB8 0.0003667289893260514
FMODE44_9 0 n46 V_PCB9 -0.0050474835567354444
FMODE44_10 0 n46 V_PCB10 7.8792756621768955e-05
FMODE44_11 0 n46 V_PCB11 0.0040490314414149235
FMODE44_12 0 n46 V_PCB12 0.0016922896658382333
FMODE44_13 0 n46 V_PCB13 0.0042243324886964244
FMODE44_14 0 n46 V_PCB14 0.0023774678258444773
FMODE44_15 0 n46 V_PCB15 0.0027121094858787637
FMODE44_16 0 n46 V_PCB16 0.0028134377542585478
FMODE44_17 0 n46 V_PCB17 -5.069168340658369e-05
FMODE44_18 0 n46 V_PCB18 0.001389987231968999
FMODE44_19 0 n46 V_PCB19 0.00204674315915075
FMODE44_20 0 n46 V_PCB20 0.00023995425683846343
FMODE44_21 0 n46 V_PCB21 0.0024705610736398824
FMODE44_22 0 n46 V_PCB22 0.0015908489788624878
FMODE44_23 0 n46 V_PCB23 0.0017312283424032152
RMODE44 n46 0 1
LMODE44 n46 0 3.4288893048723013e-06 IC=-0.00012558415228379845
FMODE45_0 0 n47 V_PCB0 -6.8308407435128005e-05
FMODE45_1 0 n47 V_PCB1 -0.00075038866887005185
FMODE45_2 0 n47 V_PCB2 -0.00030547599033025193
FMODE45_3 0 n47 V_PCB3 0.00037690102485090537
FMODE45_4 0 n47 V_PCB4 2.0777278598553645e-05
FMODE45_5 0 n47 V_PCB5 0.0007865960571746645
FMODE45_6 0 n47 V_PCB6 0.00026322323497270594
FMODE45_7 0 n47 V_PCB7 0.00098531853745549721
FMODE45_8 0 n47 V_PCB8 0.00031836815714931849
FMODE45_9 0 n47 V_PCB9 0.0010102459344496786
FMODE45_10 0 n47 V_PCB10 0.00014497558526301854
FMODE45_11 0 n47 V_PCB11 0.0061918514023309602
FMODE45_12 0 n47 V_PCB12 -0.0078168531051848594
FMODE45_13 0 n47 V_PCB13 0.0050441104249725954
FMODE45_14 0 n47 V_PCB14 -0.0072303123847358517
FMODE45_15 0 n47 V_PCB15 0.0029919148142454103
FMODE45_16 0 n47 V_PCB16 -0.0075275626019450188
FMODE45_17 0 n47 V_PCB17 0.00067552570866595486
FMODE45_18 0 n47 V_PCB18 0.00077193720038047186
FMODE45_19 0 n47 V_PCB19 0.00052851809747357268
FMODE45_20 0 n47 V_PCB20 0.0010285089340901926
FMODE45_21 0 n47 V_PCB21 0.0035286805401141155
FMODE45_22 0 n47 V_PCB22 -0.0015484798124818483
FMODE45_23 0 n47 V_PCB23 0.0013052647632635324
RMODE45 n47 0 1
LMODE45 n47 0 3.4288893048723013e-06 IC=0.00053194793851081882
FMODE46_0 0 n48 V_PCB0 0.00049495148756175267
FMODE46_1 0 n48 V_PCB1 0.0020872982954134763
FMODE46_2 0 n48 V_PCB2 0.002919465157242165
FMODE46_3 0 n48 V_PCB3 -0.0010710427971237486
FMODE46_4 0 n48 V_PCB4 0.0032244690236346374
FMODE46_5 0 n48 V_PCB5 -0.0029129692187766679
FMODE46_6 0 n48 V_PCB6 0.0028919575791202922
FMODE46_7 0 n48 V_PCB7 -0.0049446050359977988
FMODE46_8 0 n48 V_PCB8 0.0021980094094263057
FMODE46_9 0 n48 V_PCB9 -0.0068737032190878218
FMODE46_10 0 n48 V_PCB10 0.0011311028586977652
FMODE46_11 0 n48 V_PCB11 -0.0075534884711107612
FMODE46_12 0 n48 V_PCB12 -0.0053184857922891722
FMODE46_13 0 n48 V_PCB13 -0.0056040722405799456
FMODE46_14 0 n48 V_PCB14 -0.0041745414541065643
FMODE46_15 0 n48 V_PCB15 -0.0028354709813247477
FMODE46_16 0 n48 V_PCB16 -0.0030550715374356016
FMODE46_17 0 n48 V_PCB17 -0.00064726085520028578
FMODE46_18 0 n48 V_PCB18 0.0025438879447636539
FMODE46_19 0 n48 V_PCB19 0.0025351634387568468
FMODE46_20 0 n48 V_PCB20 -0.00060671187917472468
FMODE46_21 0 n48 V_PCB21 0.00042424953089519496
FMODE46_22 0 n48 V_PCB22 -0.00036158011919996161
FMODE46_23 0 n48 V_PCB23 -0.000169609368249868
RMODE46 n48 0 1
LMODE46 n48 0 3.4288893048723013e-06 IC=-0.00050657021367363426
FMODE47_0 0 n49 V_PCB0 0.00030976635665576975
FMODE47_1 0 n49 V_PCB1 -0.00075626483947019072
FMODE47_2 0 n49 V_PCB2 -0.0010097836167133481
FMODE47_3 0 n49 V_PCB3 -0.00025934290508944542
FMODE47_4 0 n49 V_PCB4 -0.0013548102256586924
FMODE47_5 0 n49 V_PCB5 -0.00042350111745045492
FMODE47_6 0 n49 V_PCB6 -0.0016282487597120351
FMODE47_7 0 n49 V_PCB7 -0.0004555293394303948
FMODE47_8 0 n49 V_PCB8 -0.0018417761831100116
FMODE47_9 0 n49 V_PCB9 -0.00022758646792442056
FMODE47_10 0 n49 V_PCB10 -0.0021956085603100362
FMODE47_11 0 n49 V_PCB11 -0.0030039904246493103
FMODE47_12 0 n49 V_PCB12 -0.00028717668464958539
FMODE47_13 0 n49 V_PCB13 -0.0018807410089717105
FMODE47_14 0 n49 V_PCB14 0.0003746561940276858
FMODE47_15 0 n49 V_PCB15 -0.00085926575535989985
FMODE47_16 0 n49 V_PCB16 0.00093275497538617737
FMODE47_17 0 n49 V_PCB17 0.01322959363015363
FMODE47_18 0 n49 V_PCB18 -0.00027847202360704794
FMODE47_19 0 n49 V_PCB19 -0.00062554298905432041
FMODE47_20 0 n49 V_PCB20 0.012785990571889663
FMODE47_21 0 n49 V_PCB21 0.0035254672967464625
FMODE47_22 0 n49 V_PCB22 0.00045608127101783708
FMODE47_23 0 n49 V_PCB23 0.0049672547793139857
RMODE47 n49 0 1
LMODE47 n49 0 3.4288893048723013e-06 IC=0.0010556040000947143
FMODE48_0 0 n50 V_PCB0 0.0022926443897060642
FMODE48_1 0 n50 V_PCB1 -0.002745419812242952
FMODE48_2 0 n50 V_PCB2 -0.0053532938457239174
FMODE48_3 0 n50 V_PCB3 -0.0024616015274282381
FMODE48_4 0 n50 V_PCB4 -0.0074321156526475553
FMODE48_5 0 n50 V_PCB5 -0.0049468586753258883
FMODE48_6 0 n50 V_PCB6 -0.0093428805472947872
FMODE48_7 0 n50 V_PCB7 -0.0069362210131527907
FMODE48_8 0 n50 V_PCB8 -0.010736280641136343
FMODE48_9 0 n50 V_PCB9 -0.008630999233902821
FMODE48_10 0 n50 V_PCB10 -0.011927392784357237
FMODE48_11 0 n50 V_PCB11 -0.00025963369715767501
FMODE48_12 0 n50 V_PCB12 -0.002791630715233672
FMODE48_13 0 n50 V_PCB13 -0.000184609507711168
FMODE48_14 0 n50 V_PCB14 -0.0027011050588255799
FMODE48_15 0 n50 V_PCB15 -3.0756605340857825e-05
FMODE48_16 0 n50 V_PCB16 -0.0026447675443614939
FMODE48_17 0 n50 V_PCB17 -0.0012703988176640231
FMODE48_18 0 n50 V_PCB18 -0.0057691885417079551
FMODE48_19 0 n50 V_PCB19 -0.010742500540378931
FMODE48_20 0 n50 V_PCB20 -0.0019985677064523052
FMODE48_21 0 n50 V_PCB21 -0.0032249249767068461
FMODE48_22 0 n50 V_PCB22 -0.00059763696793022634
FMODE48_23 0 n50 V_PCB23 -0.00807149232201799
RMODE48 n50 0 1
LMODE48 n50 0 3.4288893048723013e-06 IC=0.00073578402014052842
FMODE49_0 0 n51 V_PCB0 -0.0010130530463009822
FMODE49_1 0 n51 V_PCB1 0.0037337935060620781
FMODE49_2 0 n51 V_PCB2 0.0040601671694724829
FMODE49_3 0 n51 V_PCB3 9.1112571162812821e-06
FMODE49_4 0 n51 V_PCB4 0.0044663914229746519
FMODE49_5 0 n51 V_PCB5 -0.00055063808727737976
FMODE49_6 0 n51 V_PCB6 0.0044788277826825745
FMODE49_7 0 n51 V_PCB7 -0.00135129256461695
FMODE49_8 0 n51 V_PCB8 0.0042510045771365504
FMODE49_9 0 n51 V_PCB9 -0.0024580785954848162
FMODE49_10 0 n51 V_PCB10 0.004391949353177986
FMODE49_11 0 n51 V_PCB11 0.0066624186271408261
FMODE49_12 0 n51 V_PCB12 0.0010774555570176763
FMODE49_13 0 n51 V_PCB13 0.0042839113099416492
FMODE49_14 0 n51 V_PCB14 -0.0004994571056185054
FMODE49_15 0 n51 V_PCB15 0.001915546468583741
FMODE49_16 0 n51 V_PCB16 -0.0023342692862296007
FMODE49_17 0 n51 V_PCB17 0.01048647328672395
FMODE49_18 0 n51 V_PCB18 0.0008249172452672826
FMODE49_19 0 n51 V_PCB19 0.0016528235799765716
FMODE49_20 0 n51 V_PCB20 0.0078241492132730562
FMODE49_21 0 n51 V_PCB21 -0.019917294747840621
FMODE49_22 0 n51 V_PCB22 -0.0018348184460899913
FMODE49_23 0 n51 V_PCB23 -0.01961137352748106
RMODE49 n51 0 1
LMODE49 n51 0 3.4288893048723013e-06 IC=-0.004219292366810859
FMODE50_0 0 n52 V_PCB0 -0.0034567111601614868
FMODE50_1 0 n52 V_PCB1 0.0018144721080664351
FMODE50_2 0 n52 V_PCB2 0.0033079690846830627
FMODE50_3 0 n52 V_PCB3 -0.00094293698095650853
FMODE50_4 0 n52 V_PCB4 0.0017855756865643101
FMODE50_5 0 n52 V_PCB5 -0.0022236142618012387
FMODE50_6 0 n52 V_PCB6 -0.0014003301103771605
FMODE50_7 0 n52 V_PCB7 -0.0027833519537450446
FMODE50_8 0 n52 V_PCB8 -0.0032362421382668874
FMODE50_9 0 n52 V_PCB9 -0.0030593131808669427
FMODE50_10 0 n52 V_PCB10 -0.0036825999180019652
FMODE50_11 0 n52 V_PCB11 0.00024881315663863502
FMODE50_12 0 n52 V_PCB12 0.000838688549958538
FMODE50_13 0 n52 V_PCB13 -0.00062907275634173484
FMODE50_14 0 n52 V_PCB14 0.0001439535451198175
FMODE50_15 0 n52 V_PCB15 -0.0012948671923518553
FMODE50_16 0 n52 V_PCB16 -0.0010162786113525628
FMODE50_17 0 n52 V_PCB17 -0.00056286198270212638
FMODE50_18 0 n52 V_PCB18 0.0042444204731333741
FMODE50_19 0 n52 V_PCB19 -0.0023630188963247646
FMODE50_20 0 n52 V_PCB20 0.00031608368521673566
FMODE50_21 0 n52 V_PCB21 0.0020097870886381444
FMODE50_22 0 n52 V_PCB22 -0.0017739043717040694
FMODE50_23 0 n52 V_PCB23 -0.0013568233871662056
RMODE50 n52 0 1
LMODE50 n52 0 7.3873180666961923e-07 IC=-3.7511960410585587e-05
FMODE51_0 0 n53 V_PCB0 0.0015091815821362752
FMODE51_1 0 n53 V_PCB1 0.0029104920305611003
FMODE51_2 0 n53 V_PCB2 0.0034607034486981362
FMODE51_3 0 n53 V_PCB3 0.0023125637461305056
FMODE51_4 0 n53 V_PCB4 0.0021471244608343783
FMODE51_5 0 n53 V_PCB5 0.0042547697417789467
FMODE51_6 0 n53 V_PCB6 4.4571523005062778e-05
FMODE51_7 0 n53 V_PCB7 0.0049675670962378727
FMODE51_8 0 n53 V_PCB8 -0.0016087423543031177
FMODE51_9 0 n53 V_PCB9 0.0044877170789564087
FMODE51_10 0 n53 V_PCB10 -0.0021038373777655297
FMODE51_11 0 n53 V_PCB11 0.00027442899400061869
FMODE51_12 0 n53 V_PCB12 -0.00073929977836275946
FMODE51_13 0 n53 V_PCB13 0.00081016757616605734
FMODE51_14 0 n53 V_PCB14 -0.00011321750074253326
FMODE51_15 0 n53 V_PCB15 0.0011762278105849186
FMODE51_16 0 n53 V_PCB16 0.00085668930344426786
FMODE51_17 0 n53 V_PCB17 0.00043320930247027527
FMODE51_18 0 n53 V_PCB18 0.0040192869250021464
FMODE51_19 0 n53 V_PCB19 -0.0029449649742182976
FMODE51_20 0 n53 V_PCB20 -0.00077800487953865816
FMODE51_21 0 n53 V_PCB21 -0.0027811227082713708
FMODE51_22 0 n53 V_PCB22 0.00069070701389949997
FMODE51_23 0 n53 V_PCB23 0.0016823880505833055
RMODE51 n53 0 1
LMODE51 n53 0 7.3873180666961923e-07 IC=-0.00018588977804824092
FMODE52_0 0 n54 V_PCB0 -0.00036083372605262033
FMODE52_1 0 n54 V_PCB1 0.00042725003529139703
FMODE52_2 0 n54 V_PCB2 1.5580371186348812e-05
FMODE52_3 0 n54 V_PCB3 -0.0012889872047746706
FMODE52_4 0 n54 V_PCB4 -0.00036751386901718198
FMODE52_5 0 n54 V_PCB5 -0.0025147098292209696
FMODE52_6 0 n54 V_PCB6 -0.00067721673756325799
FMODE52_7 0 n54 V_PCB7 -0.0031398178773711363
FMODE52_8 0 n54 V_PCB8 -0.0008560568654959593
FMODE52_9 0 n54 V_PCB9 -0.0026403907942836318
FMODE52_10 0 n54 V_PCB10 -0.001183392370689123
FMODE52_11 0 n54 V_PCB11 -0.00035122333558479168
FMODE52_12 0 n54 V_PCB12 -0.00050966281020115305
FMODE52_13 0 n54 V_PCB13 -0.00019581604917939363
FMODE52_14 0 n54 V_PCB14 -3.9243962954484831e-05
FMODE52_15 0 n54 V_PCB15 -3.467654813898922e-05
FMODE52_16 0 n54 V_PCB16 0.0004634460417476829
FMODE52_17 0 n54 V_PCB17 7.9174219247917643e-05
FMODE52_18 0 n54 V_PCB18 -0.00016504940821893688
FMODE52_19 0 n54 V_PCB19 0.00051547916723625263
FMODE52_20 0 n54 V_PCB20 -0.00081366252016984452
FMODE52_21 0 n54 V_PCB21 -0.0076241709349469892
FMODE52_22 0 n54 V_PCB22 0.00075370877135724854
FMODE52_23 0 n54 V_PCB23 0.0098870528026774717
RMODE52 n54 0 1
LMODE52 n54 0 7.3873180666961923e-07 IC=0.00023077540423601533
FMODE53_0 0 n55 V_PCB0 -3.6196297023441938e-05
FMODE53_1 0 n55 V_PCB1 -0.00024675105264067678
FMODE53_2 0 n55 V_PCB2 -0.00023557952871676335
FMODE53_3 0 n55 V_PCB3 -0.00062613914127479747
FMODE53_4 0 n55 V_PCB4 -0.00028531098037509387
FMODE53_5 0 n55 V_PCB5 -0.0011783415901467449
FMODE53_6 0 n55 V_PCB6 -0.00040081122111931903
FMODE53_7 0 n55 V_PCB7 -0.0014409577382662139
FMODE53_8 0 n55 V_PCB8 -0.00041744926549920847
FMODE53_9 0 n55 V_PCB9 -0.0011199292632999127
FMODE53_10 0 n55 V_PCB10 -0.00019982230997156908
FMODE53_11 0 n55 V_PCB11 0.011955813345702922
FMODE53_12 0 n55 V_PCB12 -0.0011194350557332971
FMODE53_13 0 n55 V_PCB13 0.01088428632506697
FMODE53_14 0 n55 V_PCB14 -0.00051490483632461617
FMODE53_15 0 n55 V_PCB15 0.0068740914195801047
FMODE53_16 0 n55 V_PCB16 -0.00093149968162547895
FMODE53_17 0 n55 V_PCB17 -0.00049951218831700318
FMODE53_18 0 n55 V_PCB18 0.00015964327733549135
FMODE53_19 0 n55 V_PCB19 0.00029241763191390808
FMODE53_20 0 n55 V_PCB20 1.6174443738381246e-05
FMODE53_21 0 n55 V_PCB21 -0.00083028963035348252
FMODE53_22 0 n55 V_PCB22 -0.00053170836088456809
FMODE53_23 0 n55 V_PCB23 -0.0011850995411065847
RMODE53 n55 0 1
LMODE53 n55 0 7.3873180666961923e-07 IC=-0.0002757530038751734
FMODE54_0 0 n56 V_PCB0 0.0001212492239905612
FMODE54_1 0 n56 V_PCB1 0.0037892989299338855
FMODE54_2 0 n56 V_PCB2 0.0056748953144590171
FMODE54_3 0 n56 V_PCB3 -0.0001820132169338542
FMODE54_4 0 n56 V_PCB4 0.0059170698333088209
FMODE54_5 0 n56 V_PCB5 -0.0006609247654757491
FMODE54_6 0 n56 V_PCB6 0.0062437670575292269
FMODE54_7 0 n56 V_PCB7 -0.0010728311185645033
FMODE54_8 0 n56 V_PCB8 0.006285655226083528
FMODE54_9 0 n56 V_PCB9 -0.00037738330187045649
FMODE54_10 0 n56 V_PCB10 0.0058212469221797852
FMODE54_11 0 n56 V_PCB11 0.0017027881155073433
FMODE54_12 0 n56 V_PCB12 0.0081846627334074568
FMODE54_13 0 n56 V_PCB13 0.0018849684369691578
FMODE54_14 0 n56 V_PCB14 0.007561058863583668
FMODE54_15 0 n56 V_PCB15 0.001328400174568093
FMODE54_16 0 n56 V_PCB16 0.0070624887453247711
FMODE54_17 0 n56 V_PCB17 0.0020638595622403115
FMODE54_18 0 n56 V_PCB18 0.0057824003340548671
FMODE54_19 0 n56 V_PCB19 0.0074203411529468006
FMODE54_20 0 n56 V_PCB20 0.0020976450265348047
FMODE54_21 0 n56 V_PCB21 0.012606925576701549
FMODE54_22 0 n56 V_PCB22 0.0038358012167383848
FMODE54_23 0 n56 V_PCB23 0.010605258752103278
RMODE54 n56 0 1
LMODE54 n56 0 7.3873180666961923e-07 IC=0.00069065195333784641
FMODE55_0 0 n57 V_PCB0 0.00033110506530199119
FMODE55_1 0 n57 V_PCB1 -0.0025427083046296655
FMODE55_2 0 n57 V_PCB2 -0.0040172041024957549
FMODE55_3 0 n57 V_PCB3 -0.00017564660451754359
FMODE55_4 0 n57 V_PCB4 -0.0045071606241683928
FMODE55_5 0 n57 V_PCB5 -0.00020158383619176036
FMODE55_6 0 n57 V_PCB6 -0.0052113580498192522
FMODE55_7 0 n57 V_PCB7 -0.0001343254320204627
FMODE55_8 0 n57 V_PCB8 -0.0056091272601913765
FMODE55_9 0 n57 V_PCB9 2.1325261298067266e-05
FMODE55_10 0 n57 V_PCB10 -0.0052664069686410939
FMODE55_11 0 n57 V_PCB11 0.0005304984323370839
FMODE55_12 0 n57 V_PCB12 0.016302866266779504
FMODE55_13 0 n57 V_PCB13 0.0010743702164043389
FMODE55_14 0 n57 V_PCB14 0.015123644253257636
FMODE55_15 0 n57 V_PCB15 0.0008630577223169366
FMODE55_16 0 n57 V_PCB16 0.014430363861335269
FMODE55_17 0 n57 V_PCB17 0.0013930352503357991
FMODE55_18 0 n57 V_PCB18 -0.004491641064405888
FMODE55_19 0 n57 V_PCB19 -0.0065333763975000481
FMODE55_20 0 n57 V_PCB20 0.0013055699824857652
FMODE55_21 0 n57 V_PCB21 -0.0064512379513076779
FMODE55_22 0 n57 V_PCB22 0.0055859327712820339
FMODE55_23 0 n57 V_PCB23 -0.006394785784593425
RMODE55 n57 0 1
LMODE55 n57 0 7.3873180666961923e-07 IC=-0.00082334320697685713
FMODE56_0 0 n58 V_PCB0 0.0017584693108057981
FMODE56_1 0 n58 V_PCB1 -0.0054359651390662508
FMODE56_2 0 n58 V_PCB2 -0.0071137387369400494
FMODE56_3 0 n58 V_PCB3 0.00098477888900150128
FMODE56_4 0 n58 V_PCB4 -0.0079650712646451103
FMODE56_5 0 n58 V_PCB5 0.002127946870277011
FMODE56_6 0 n58 V_PCB6 -0.0085089790329548037
FMODE56_7 0 n58 V_PCB7 0.0029735220903143651
FMODE56_8 0 n58 V_PCB8 -0.0086167018806184974
FMODE56_9 0 n58 V_PCB9 0.0040767862414124185
FMODE56_10 0 n58 V_PCB10 -0.0086091737172396248
FMODE56_11 0 n58 V_PCB11 0.001403426031845854
FMODE56_12 0 n58 V_PCB12 -0.0026693558018874505
FMODE56_13 0 n58 V_PCB13 0.00095728168645622133
FMODE56_14 0 n58 V_PCB14 -0.0025029406615013992
FMODE56_15 0 n58 V_PCB15 0.0004529949614287275
FMODE56_16 0 n58 V_PCB16 -0.0026633681120887221
FMODE56_17 0 n58 V_PCB17 0.012318376841670033
FMODE56_18 0 n58 V_PCB18 -0.0045412681464980509
FMODE56_19 0 n58 V_PCB19 -0.0073049426944405719
FMODE56_20 0 n58 V_PCB20 0.012261355313351954
FMODE56_21 0 n58 V_PCB21 0.016360185551378567
FMODE56_22 0 n58 V_PCB22 -0.00050216811361891581
FMODE56_23 0 n58 V_PCB23 0.014274757370759658
RMODE56 n58 0 1
LMODE56 n58 0 7.3873180666961923e-07 IC=0.0048414647618186578
FMODE57_0 0 n59 V_PCB0 -0.00060157845028495111
FMODE57_1 0 n59 V_PCB1 0.0030887776402816662
FMODE57_2 0 n59 V_PCB2 0.0041950955263634288
FMODE57_3 0 n59 V_PCB3 -0.00077343549339643346
FMODE57_4 0 n59 V_PCB4 0.0044017267372596335
FMODE57_5 0 n59 V_PCB5 -0.0015611707444481797
FMODE57_6 0 n59 V_PCB6 0.0044175814034721353
FMODE57_7 0 n59 V_PCB7 -0.0021629681441898618
FMODE57_8 0 n59 V_PCB8 0.0043255163859788979
FMODE57_9 0 n59 V_PCB9 -0.003016214828774383
FMODE57_10 0 n59 V_PCB10 0.0041306841315369965
FMODE57_11 0 n59 V_PCB11 -0.00080345444801335764
FMODE57_12 0 n59 V_PCB12 -0.001363944926736206
FMODE57_13 0 n59 V_PCB13 -0.00053079880067983176
FMODE57_14 0 n59 V_PCB14 -0.0011473282336573842
FMODE57_15 0 n59 V_PCB15 -0.00016934199887969604
FMODE57_16 0 n59 V_PCB16 -0.00094254440490494369
FMODE57_17 0 n59 V_PCB17 0.025946386253449208
FMODE57_18 0 n59 V_PCB18 0.0038860626646288537
FMODE57_19 0 n59 V_PCB19 0.0042139611108297009
FMODE57_20 0 n59 V_PCB20 0.023992245591785803
FMODE57_21 0 n59 V_PCB21 -0.013443818138983063
FMODE57_22 0 n59 V_PCB22 -0.00056561233525230883
FMODE57_23 0 n59 V_PCB23 -0.0095994564529863231
RMODE57 n59 0 1
LMODE57 n59 0 7.3873180666961923e-07 IC=-0.0032197672069110188
FMODE58_0 0 n60 V_PCB0 0.00051150896679787725
FMODE58_1 0 n60 V_PCB1 0.0016350190719482012
FMODE58_2 0 n60 V_PCB2 0.0017090095290312579
FMODE58_3 0 n60 V_PCB3 -0.0024973684959101916
FMODE58_4 0 n60 V_PCB4 0.0013322518907157323
FMODE58_5 0 n60 V_PCB5 -0.0043552751200280852
FMODE58_6 0 n60 V_PCB6 0.001039856488995315
FMODE58_7 0 n60 V_PCB7 -0.0058632892076554708
FMODE58_8 0 n60 V_PCB8 0.00055325464235169276
FMODE58_9 0 n60 V_PCB9 -0.0090477095104501727
FMODE58_10 0 n60 V_PCB10 -0.00046747296177957181
FMODE58_11 0 n60 V_PCB11 0.0021405662180594216
FMODE58_12 0 n60 V_PCB12 0.00015683648504537652
FMODE58_13 0 n60 V_PCB13 0.0016593674729358705
FMODE58_14 0 n60 V_PCB14 0.000361160907360543
FMODE58_15 0 n60 V_PCB15 0.001085266339535594
FMODE58_16 0 n60 V_PCB16 0.00076209082966634115
FMODE58_17 0 n60 V_PCB17 0.00018696990816964134
FMODE58_18 0 n60 V_PCB18 0.0018699182247112129
FMODE58_19 0 n60 V_PCB19 0.00070586453358086477
FMODE58_20 0 n60 V_PCB20 0.001708932915963369
FMODE58_21 0 n60 V_PCB21 0.010687953645004578
FMODE58_22 0 n60 V_PCB22 0.0010988836123684575
FMODE58_23 0 n60 V_PCB23 -0.0053800259966535254
RMODE58 n60 0 1
LMODE58 n60 0 1.5915494309189535e-07 IC=1.2519571386456927e-05
FMODE59_0 0 n61 V_PCB0 -0.00019443936760107699
FMODE59_1 0 n61 V_PCB1 -0.0011120279138644325
FMODE59_2 0 n61 V_PCB2 -0.00096698568332342916
FMODE59_3 0 n61 V_PCB3 0.0015963324059234587
FMODE59_4 0 n61 V_PCB4 -0.00066976005212447784
FMODE59_5 0 n61 V_PCB5 0.0025861906416565186
FMODE59_6 0 n61 V_PCB6 -0.00050784182938517065
FMODE59_7 0 n61 V_PCB7 0.0031525823029595035
FMODE59_8 0 n61 V_PCB8 -0.00037492559159477937
FMODE59_9 0 n61 V_PCB9 0.0039217407945680632
FMODE59_10 0 n61 V_PCB10 9.7184819943886533e-06
FMODE59_11 0 n61 V_PCB11 0.014832947986289945
FMODE59_12 0 n61 V_PCB12 0.0015697786183355438
FMODE59_13 0 n61 V_PCB13 0.011428089875326149
FMODE59_14 0 n61 V_PCB14 0.00064520624645969288
FMODE59_15 0 n61 V_PCB15 0.0059975558651853347
FMODE59_16 0 n61 V_PCB16 -0.00053802207883364012
FMODE59_17 0 n61 V_PCB17 0.00017598456623766877
FMODE59_18 0 n61 V_PCB18 -0.0011669696463118115
FMODE59_19 0 n61 V_PCB19 -0.00058651734311197812
FMODE59_20 0 n61 V_PCB20 0.00086350876147399847
FMODE59_21 0 n61 V_PCB21 0.0031920804310729477
FMODE59_22 0 n61 V_PCB22 0.00051100140414079035
FMODE59_23 0 n61 V_PCB23 0.0030600565155370477
RMODE59 n61 0 1
LMODE59 n61 0 1.5915494309189535e-07 IC=0.00076570780156271943
FMODE60_0 0 n62 V_PCB0 0.00087933942043837653
FMODE60_1 0 n62 V_PCB1 -0.0021066720774291156
FMODE60_2 0 n62 V_PCB2 -0.0015270489706552331
FMODE60_3 0 n62 V_PCB3 0.0015288940382472862
FMODE60_4 0 n62 V_PCB4 -0.0011618929434354835
FMODE60_5 0 n62 V_PCB5 0.0023199728108747476
FMODE60_6 0 n62 V_PCB6 -0.0011666832940738824
FMODE60_7 0 n62 V_PCB7 0.0027902692683029946
FMODE60_8 0 n62 V_PCB8 -0.0011689103886516937
FMODE60_9 0 n62 V_PCB9 0.0038198453512807177
FMODE60_10 0 n62 V_PCB10 -0.00068969260084010846
FMODE60_11 0 n62 V_PCB11 -0.0065216694640727376
FMODE60_12 0 n62 V_PCB12 -0.001469251710355095
FMODE60_13 0 n62 V_PCB13 -0.0045540628705447962
FMODE60_14 0 n62 V_PCB14 0.00037547646326175889
FMODE60_15 0 n62 V_PCB15 -0.0021844137733542305
FMODE60_16 0 n62 V_PCB16 0.0021976840062479714
FMODE60_17 0 n62 V_PCB17 0.0076860079039814217
FMODE60_18 0 n62 V_PCB18 -0.00027698713085550555
FMODE60_19 0 n62 V_PCB19 0.00073881511856373368
FMODE60_20 0 n62 V_PCB20 0.010364207203947521
FMODE60_21 0 n62 V_PCB21 0.017090050363410318
FMODE60_22 0 n62 V_PCB22 0.002148893041136391
FMODE60_23 0 n62 V_PCB23 0.02013571277638642
RMODE60 n62 0 1
LMODE60 n62 0 1.5915494309189535e-07 IC=0.0035924689916651143
FMODE61_0 0 n63 V_PCB0 0.00032242829551223522
FMODE61_1 0 n63 V_PCB1 0.0029904339044917795
FMODE61_2 0 n63 V_PCB2 0.0042412136222320209
FMODE61_3 0 n63 V_PCB3 4.5223223942277954e-05
FMODE61_4 0 n63 V_PCB4 0.0046683084222985524
FMODE61_5 0 n63 V_PCB5 0.00012750910272340686
FMODE61_6 0 n63 V_PCB6 0.0052342322416051388
FMODE61_7 0 n63 V_PCB7 0.00021809189995056883
FMODE61_8 0 n63 V_PCB8 0.0055362498773142404
FMODE61_9 0 n63 V_PCB9 0.00018200140859362014
FMODE61_10 0 n63 V_PCB10 0.0057819637718652889
FMODE61_11 0 n63 V_PCB11 0.0016368921251192117
FMODE61_12 0 n63 V_PCB12 -0.019681068357438387
FMODE61_13 0 n63 V_PCB13 0.0013590692225646419
FMODE61_14 0 n63 V_PCB14 -0.019374011463690735
FMODE61_15 0 n63 V_PCB15 0.00073883028013663145
FMODE61_16 0 n63 V_PCB16 -0.01928627049545318
FMODE61_17 0 n63 V_PCB17 0.00054477441050043555
FMODE61_18 0 n63 V_PCB18 0.003276941648532324
FMODE61_19 0 n63 V_PCB19 0.0046670434360855766
FMODE61_20 0 n63 V_PCB20 0.00057559532967914535
FMODE61_21 0 n63 V_PCB21 0.0010088743971412302
FMODE61_22 0 n63 V_PCB22 -0.0075023171505812034
FMODE61_23 0 n63 V_PCB23 0.0028915068530580854
RMODE61 n63 0 1
LMODE61 n63 0 1.5915494309189535e-07 IC=0.00038559218942872995
FMODE62_0 0 n64 V_PCB0 0.00024221165511750356
FMODE62_1 0 n64 V_PCB1 -0.0060749213260769021
FMODE62_2 0 n64 V_PCB2 -0.0091716053674359491
FMODE62_3 0 n64 V_PCB3 -0.0012611812273097618
FMODE62_4 0 n64 V_PCB4 -0.010493388458686428
FMODE62_5 0 n64 V_PCB5 -0.0026354805188486099
FMODE62_6 0 n64 V_PCB6 -0.011999339850005914
FMODE62_7 0 n64 V_PCB7 -0.0038041815457289184
FMODE62_8 0 n64 V_PCB8 -0.013092906190965098
FMODE62_9 0 n64 V_PCB9 -0.0053855121290048834
FMODE62_10 0 n64 V_PCB10 -0.014340432369385163
FMODE62_11 0 n64 V_PCB11 0.0011815508272563612
FMODE62_12 0 n64 V_PCB12 -0.0069227680182843386
FMODE62_13 0 n64 V_PCB13 0.00085108525113340597
FMODE62_14 0 n64 V_PCB14 -0.0069981754555458672
FMODE62_15 0 n64 V_PCB15 0.00049364211663090825
FMODE62_16 0 n64 V_PCB16 -0.0070683611555225649
FMODE62_17 0 n64 V_PCB17 0.013804352281937604
FMODE62_18 0 n64 V_PCB18 -0.0083348944672836552
FMODE62_19 0 n64 V_PCB19 -0.013978126781145381
FMODE62_20 0 n64 V_PCB20 0.012473523177532557
FMODE62_21 0 n64 V_PCB21 -0.0058090973072167729
FMODE62_22 0 n64 V_PCB22 -0.0025016682089578253
FMODE62_23 0 n64 V_PCB23 -0.0070139062239196479
RMODE62 n64 0 1
LMODE62 n64 0 1.5915494309189535e-07 IC=0.0014986053074150002
FMODE63_0 0 n65 V_PCB0 -0.00038931722174844965
FMODE63_1 0 n65 V_PCB1 0.00504859978652726
FMODE63_2 0 n65 V_PCB2 0.0067568007933603499
FMODE63_3 0 n65 V_PCB3 0.00016163339656739942
FMODE63_4 0 n65 V_PCB4 0.00736655641801347
FMODE63_5 0 n65 V_PCB5 0.00061225322890272706
FMODE63_6 0 n65 V_PCB6 0.0080686421913021191
FMODE63_7 0 n65 V_PCB7 0.0010473955251607547
FMODE63_8 0 n65 V_PCB8 0.0086231911674862927
FMODE63_9 0 n65 V_PCB9 0.0013613830428865037
FMODE63_10 0 n65 V_PCB10 0.0091835021641813626
FMODE63_11 0 n65 V_PCB11 0.0023352042028897562
FMODE63_12 0 n65 V_PCB12 0.0056000020766167309
FMODE63_13 0 n65 V_PCB13 0.0015068554465990926
FMODE63_14 0 n65 V_PCB14 0.0046448882511114214
FMODE63_15 0 n65 V_PCB15 0.00062714234160126531
FMODE63_16 0 n65 V_PCB16 0.0037444957583129064
FMODE63_17 0 n65 V_PCB17 0.025679397854281825
FMODE63_18 0 n65 V_PCB18 0.0056993682766466108
FMODE63_19 0 n65 V_PCB19 0.0081397922401475094
FMODE63_20 0 n65 V_PCB20 0.023669702079605792
FMODE63_21 0 n65 V_PCB21 -0.012731164652664499
FMODE63_22 0 n65 V_PCB22 0.00047934672132791701
FMODE63_23 0 n65 V_PCB23 -0.0080936060590659081
RMODE63 n65 0 1
LMODE63 n65 0 1.5915494309189535e-07 IC=-0.0037270862136116771
FMODE64_0 0 n66 V_PCB0 4.273209001447312e-05
FMODE64_1 0 n66 V_PCB1 -0.00586198667003833
FMODE64_2 0 n66 V_PCB2 -0.0092524794433766835
FMODE64_3 0 n66 V_PCB3 -0.0018073856626687756
FMODE64_4 0 n66 V_PCB4 -0.013282526286645415
FMODE64_5 0 n66 V_PCB5 -0.0038772429481399155
FMODE64_6 0 n66 V_PCB6 -0.015925038645556475
FMODE64_7 0 n66 V_PCB7 -0.0054607917307795267
FMODE64_8 0 n66 V_PCB8 -0.017770941576756599
FMODE64_9 0 n66 V_PCB9 -0.0058071150980178784
FMODE64_10 0 n66 V_PCB10 -0.017713287081438323
FMODE64_11 0 n66 V_PCB11 0.0077460759665247984
FMODE64_12 0 n66 V_PCB12 0.074467957671885618
FMODE64_13 0 n66 V_PCB13 0.0061103769827907592
FMODE64_14 0 n66 V_PCB14 0.067934912718299753
FMODE64_15 0 n66 V_PCB15 0.0020063085910398933
FMODE64_16 0 n66 V_PCB16 0.062078708736717406
FMODE64_17 0 n66 V_PCB17 0.0089490468074329976
FMODE64_18 0 n66 V_PCB18 -0.013041025177704835
FMODE64_19 0 n66 V_PCB19 -0.016416894425646283
FMODE64_20 0 n66 V_PCB20 0.0010627483714567177
FMODE64_21 0 n66 V_PCB21 -0.035602776449485556
FMODE64_22 0 n66 V_PCB22 0.020974171653943406
FMODE64_23 0 n66 V_PCB23 -0.039467477207246186
RMODE64 n66 0 1
LMODE64 n66 0 1.5915494309189535e-09 IC=-0.0066029906485963377
FMODE65_0 0 n67 V_PCB0 -0.0032054985891819539
FMODE65_1 0 n67 V_PCB1 0.028019677653238186
FMODE65_2 0 n67 V_PCB2 0.038317181406042955
FMODE65_3 0 n67 V_PCB3 -0.0028031498478059197
FMODE65_4 0 n67 V_PCB4 0.045769668059797958
FMODE65_5 0 n67 V_PCB5 -0.0031860060102346715
FMODE65_6 0 n67 V_PCB6 0.051128855085227173
FMODE65_7 0 n67 V_PCB7 -0.0035212026861213214
FMODE65_8 0 n67 V_PCB8 0.053735754722664557
FMODE65_9 0 n67 V_PCB9 -0.0030602161269870699
FMODE65_10 0 n67 V_PCB10 0.054010200135277686
FMODE65_11 0 n67 V_PCB11 0.014129795573521977
FMODE65_12 0 n67 V_PCB12 0.0068978905741580695
FMODE65_13 0 n67 V_PCB13 0.0094253115276867923
FMODE65_14 0 n67 V_PCB14 0.0023580213279069499
FMODE65_15 0 n67 V_PCB15 0.005158726593445559
FMODE65_16 0 n67 V_PCB16 -0.0030202881272366902
FMODE65_17 0 n67 V_PCB17 0.060369221074060647
FMODE65_18 0 n67 V_PCB18 0.036513535177798241
FMODE65_19 0 n67 V_PCB19 0.047900854381303766
FMODE65_20 0 n67 V_PCB20 0.043592930167203635
FMODE65_21 0 n67 V_PCB21 -0.053901807783185166
FMODE65_22 0 n67 V_PCB22 -0.0028040340202721017
FMODE65_23 0 n67 V_PCB23 -0.049414768744129339
RMODE65 n67 0 1
LMODE65 n67 0 1.5915494309189535e-09 IC=-0.018914705121871038
V_PCB0 n68 n69 0
RSUM0 n70 0 1
GSUM0_0 0 n70 n2 0 -3.1263888203177764e-05
GSUM0_1 0 n70 n3 0 0.0001241290762937217
GSUM0_7 0 n70 n9 0 -0.00125778224106493
GSUM0_9 0 n70 n11 0 0.011218992706957202
GSUM0_15 0 n70 n17 0 -0.00055270837243158151
GSUM0_17 0 n70 n19 0 0.00077578187615862841
GSUM0_19 0 n70 n21 0 -0.0022396856919096901
GSUM0_24 0 n70 n26 0 2.9236693057056881e-06
GSUM0_25 0 n70 n27 0 -5.6787697511598309e-05
GSUM0_26 0 n70 n28 0 0.0055923184458819171
GSUM0_27 0 n70 n29 0 -0.00092135350173188247
GSUM0_28 0 n70 n30 0 0.00050886345315548766
GSUM0_29 0 n70 n31 0 9.7943203877975572e-07
GSUM0_30 0 n70 n32 0 0.00043553222900416121
GSUM0_31 0 n70 n33 0 7.794817520210042e-05
GSUM0_32 0 n70 n34 0 -2.283572885373068e-05
GSUM0_33 0 n70 n35 0 0.00013979528985854481
GSUM0_34 0 n70 n36 0 -0.00015938013576681043
GSUM0_35 0 n70 n37 0 0.00012644944945910684
GSUM0_36 0 n70 n38 0 7.8110841257904981e-05
GSUM0_37 0 n70 n39 0 -6.5545279568493135e-05
GSUM0_38 0 n70 n40 0 0.00037997743702521358
GSUM0_39 0 n70 n41 0 7.5429122873271845e-05
GSUM0_40 0 n70 n42 0 -0.00032629168477091227
GSUM0_41 0 n70 n43 0 -0.00017831976327143298
GSUM0_42 0 n70 n44 0 0.00016641149648320737
GSUM0_43 0 n70 n45 0 -0.00091026670974464323
GSUM0_44 0 n70 n46 0 0.001281725147947665
GSUM0_45 0 n70 n47 0 -6.8308407435128005e-05
GSUM0_46 0 n70 n48 0 0.00049495148756175267
GSUM0_47 0 n70 n49 0 0.00030976635665576975
GSUM0_48 0 n70 n50 0 0.0022926443897060642
GSUM0_49 0 n70 n51 0 -0.0010130530463009822
GSUM0_50 0 n70 n52 0 -0.0034567111601614868
GSUM0_51 0 n70 n53 0 0.0015091815821362752
GSUM0_52 0 n70 n54 0 -0.00036083372605262033
GSUM0_53 0 n70 n55 0 -3.6196297023441938e-05
GSUM0_54 0 n70 n56 0 0.0001212492239905612
GSUM0_55 0 n70 n57 0 0.00033110506530199119
GSUM0_56 0 n70 n58 0 0.0017584693108057981
GSUM0_57 0 n70 n59 0 -0.00060157845028495111
GSUM0_58 0 n70 n60 0 0.00051150896679787725
GSUM0_59 0 n70 n61 0 -0.00019443936760107699
GSUM0_60 0 n70 n62 0 0.00087933942043837653
GSUM0_61 0 n70 n63 0 0.00032242829551223522
GSUM0_62 0 n70 n64 0 0.00024221165511750356
GSUM0_63 0 n70 n65 0 -0.00038931722174844965
GSUM0_64 0 n70 n66 0 4.273209001447312e-05
GSUM0_65 0 n70 n67 0 -0.0032054985891819539
EPCB0 n69 0 n70 0 1
V_PCB1 n71 n73 0
RSUM1 n74 0 1
GSUM1_2 0 n74 n4 0 -0.00050310533920583638
GSUM1_3 0 n74 n5 0 0.001488632453948512
GSUM1_6 0 n74 n8 0 0.0026170686851077394
GSUM1_8 0 n74 n10 0 0.0038393093338165841
GSUM1_10 0 n74 n12 0 -0.0042719580502988234
GSUM1_14 0 n74 n16 0 -0.0072771042911047154
GSUM1_18 0 n74 n20 0 -0.0097749441295460985
GSUM1_23 0 n74 n25 0 0.010673595595895593
GSUM1_24 0 n74 n26 0 -1.7041174815402417e-05
GSUM1_25 0 n74 n27 0 -1.4300111243647119e-05
GSUM1_26 0 n74 n28 0 -0.00043380648775858202
GSUM1_27 0 n74 n29 0 -0.0040639747025745842
GSUM1_28 0 n74 n30 0 0.0014343137026607896
GSUM1_29 0 n74 n31 0 -0.00010728815707485224
GSUM1_30 0 n74 n32 0 0.00271782004676054
GSUM1_31 0 n74 n33 0 0.0016441433581424025
GSUM1_32 0 n74 n34 0 -0.0025827219353966313
GSUM1_33 0 n74 n35 0 0.0022549707577297585
GSUM1_34 0 n74 n36 0 -0.0020234187838958145
GSUM1_35 0 n74 n37 0 0.0034895206312777162
GSUM1_36 0 n74 n38 0 0.00035249446475107282
GSUM1_37 0 n74 n39 0 0.00016023667569583941
GSUM1_38 0 n74 n40 0 -0.00044115768328672041
GSUM1_39 0 n74 n41 0 0.00052765172110127642
GSUM1_40 0 n74 n42 0 0.01006045348770983
GSUM1_41 0 n74 n43 0 0.0037706867713513761
GSUM1_42 0 n74 n44 0 0.00075862634912522448
GSUM1_43 0 n74 n45 0 0.0016175296306032714
GSUM1_44 0 n74 n46 0 0.00092621184557206584
GSUM1_45 0 n74 n47 0 -0.00075038866887005185
GSUM1_46 0 n74 n48 0 0.0020872982954134763
GSUM1_47 0 n74 n49 0 -0.00075626483947019072
GSUM1_48 0 n74 n50 0 -0.002745419812242952
GSUM1_49 0 n74 n51 0 0.0037337935060620781
GSUM1_50 0 n74 n52 0 0.0018144721080664351
GSUM1_51 0 n74 n53 0 0.0029104920305611003
GSUM1_52 0 n74 n54 0 0.00042725003529139703
GSUM1_53 0 n74 n55 0 -0.00024675105264067678
GSUM1_54 0 n74 n56 0 0.0037892989299338855
GSUM1_55 0 n74 n57 0 -0.0025427083046296655
GSUM1_56 0 n74 n58 0 -0.0054359651390662508
GSUM1_57 0 n74 n59 0 0.0030887776402816662
GSUM1_58 0 n74 n60 0 0.0016350190719482012
GSUM1_59 0 n74 n61 0 -0.0011120279138644325
GSUM1_60 0 n74 n62 0 -0.0021066720774291156
GSUM1_61 0 n74 n63 0 0.0029904339044917795
GSUM1_62 0 n74 n64 0 -0.0060749213260769021
GSUM1_63 0 n74 n65 0 0.00504859978652726
GSUM1_64 0 n74 n66 0 -0.00586198667003833
GSUM1_65 0 n74 n67 0 0.028019677653238186
EPCB1 n73 n72 n74 0 1
V_PCB2 n75 n76 0
RSUM2 n77 0 1
GSUM2_2 0 n77 n4 0 0.0023532983049662673
GSUM2_3 0 n77 n5 0 -0.0044779414335806523
GSUM2_6 0 n77 n8 0 -0.00436151563377321
GSUM2_8 0 n77 n10 0 -0.00045208379635602473
GSUM2_10 0 n77 n12 0 0.0016198492910160665
GSUM2_14 0 n77 n16 0 -0.0012712222600675307
GSUM2_18 0 n77 n20 0 -0.0084746844150004295
GSUM2_23 0 n77 n25 0 0.014912249812935024
GSUM2_24 0 n77 n26 0 1.3882650606292043e-05
GSUM2_25 0 n77 n27 0 2.7463505678588641e-05
GSUM2_26 0 n77 n28 0 -0.00038275487249695713
GSUM2_27 0 n77 n29 0 0.0007540293049389888
GSUM2_28 0 n77 n30 0 0.00066641603104004236
GSUM2_29 0 n77 n31 0 -2.1799017438856991e-05
GSUM2_30 0 n77 n32 0 0.0013669005982087843
GSUM2_31 0 n77 n33 0 0.00080655108245747398
GSUM2_32 0 n77 n34 0 -0.0012939992533281242
GSUM2_33 0 n77 n35 0 0.0016421180380749264
GSUM2_34 0 n77 n36 0 -0.0016914589452949797
GSUM2_35 0 n77 n37 0 0.002933617138923168
GSUM2_36 0 n77 n38 0 0.00046358236864852255
GSUM2_37 0 n77 n39 0 7.6875829229639637e-05
GSUM2_38 0 n77 n40 0 0.00017159938553922211
GSUM2_39 0 n77 n41 0 0.0008243688119414852
GSUM2_40 0 n77 n42 0 0.012450914828265016
GSUM2_41 0 n77 n43 0 0.0045158550277128104
GSUM2_42 0 n77 n44 0 0.00038468579436083114
GSUM2_43 0 n77 n45 0 0.0027551796512373136
GSUM2_44 0 n77 n46 0 0.001102850591060821
GSUM2_45 0 n77 n47 0 -0.00030547599033025193
GSUM2_46 0 n77 n48 0 0.002919465157242165
GSUM2_47 0 n77 n49 0 -0.0010097836167133481
GSUM2_48 0 n77 n50 0 -0.0053532938457239174
GSUM2_49 0 n77 n51 0 0.0040601671694724829
GSUM2_50 0 n77 n52 0 0.0033079690846830627
GSUM2_51 0 n77 n53 0 0.0034607034486981362
GSUM2_52 0 n77 n54 0 1.5580371186348812e-05
GSUM2_53 0 n77 n55 0 -0.00023557952871676335
GSUM2_54 0 n77 n56 0 0.0056748953144590171
GSUM2_55 0 n77 n57 0 -0.0040172041024957549
GSUM2_56 0 n77 n58 0 -0.0071137387369400494
GSUM2_57 0 n77 n59 0 0.0041950955263634288
GSUM2_58 0 n77 n60 0 0.0017090095290312579
GSUM2_59 0 n77 n61 0 -0.00096698568332342916
GSUM2_60 0 n77 n62 0 -0.0015270489706552331
GSUM2_61 0 n77 n63 0 0.0042412136222320209
GSUM2_62 0 n77 n64 0 -0.0091716053674359491
GSUM2_63 0 n77 n65 0 0.0067568007933603499
GSUM2_64 0 n77 n66 0 -0.0092524794433766835
GSUM2_65 0 n77 n67 0 0.038317181406042955
EPCB2 n76 n72 n77 0 1
V_PCB3 n78 n79 0
RSUM3 n80 0 1
GSUM3_0 0 n80 n2 0 0.0027254813251565433
GSUM3_1 0 n80 n3 0 -0.0044865684684934478
GSUM3_7 0 n80 n9 0 0.0042367325489521363
GSUM3_9 0 n80 n11 0 0.0006210021870678798
GSUM3_15 0 n80 n17 0 -0.00027577611670097314
GSUM3_17 0 n80 n19 0 0.0037098477463128427
GSUM3_19 0 n80 n21 0 -0.0037935426488511946
GSUM3_24 0 n80 n26 0 1.2360893261788217e-06
GSUM3_25 0 n80 n27 0 4.7168643490963126e-06
GSUM3_26 0 n80 n28 0 -5.1878652940592877e-06
GSUM3_27 0 n80 n29 0 0.00018355279750863885
GSUM3_28 0 n80 n30 0 0.0012356512284862648
GSUM3_29 0 n80 n31 0 -1.3549913664558936e-05
GSUM3_30 0 n80 n32 0 -0.00019838569464663018
GSUM3_31 0 n80 n33 0 -9.6774484437408203e-05
GSUM3_32 0 n80 n34 0 0.00036114838874788452
GSUM3_33 0 n80 n35 0 0.00014133290653148243
GSUM3_34 0 n80 n36 0 -1.3100770233867264e-06
GSUM3_35 0 n80 n37 0 -0.0001342843148688771
GSUM3_36 0 n80 n38 0 -2.0838995847451484e-05
GSUM3_37 0 n80 n39 0 -3.9021029290498674e-05
GSUM3_38 0 n80 n40 0 0.00020264488025404344
GSUM3_39 0 n80 n41 0 7.2466217991121313e-06
GSUM3_40 0 n80 n42 0 6.3796421065356149e-05
GSUM3_41 0 n80 n43 0 -2.9172306288474646e-05
GSUM3_42 0 n80 n44 0 -0.00012936015500669088
GSUM3_43 0 n80 n45 0 0.00097093429356949902
GSUM3_44 0 n80 n46 0 -0.001597812745471642
GSUM3_45 0 n80 n47 0 0.00037690102485090537
GSUM3_46 0 n80 n48 0 -0.0010710427971237486
GSUM3_47 0 n80 n49 0 -0.00025934290508944542
GSUM3_48 0 n80 n50 0 -0.0024616015274282381
GSUM3_49 0 n80 n51 0 9.1112571162812821e-06
GSUM3_50 0 n80 n52 0 -0.00094293698095650853
GSUM3_51 0 n80 n53 0 0.0023125637461305056
GSUM3_52 0 n80 n54 0 -0.0012889872047746706
GSUM3_53 0 n80 n55 0 -0.00062613914127479747
GSUM3_54 0 n80 n56 0 -0.0001820132169338542
GSUM3_55 0 n80 n57 0 -0.00017564660451754359
GSUM3_56 0 n80 n58 0 0.00098477888900150128
GSUM3_57 0 n80 n59 0 -0.00077343549339643346
GSUM3_58 0 n80 n60 0 -0.0024973684959101916
GSUM3_59 0 n80 n61 0 0.0015963324059234587
GSUM3_60 0 n80 n62 0 0.0015288940382472862
GSUM3_61 0 n80 n63 0 4.5223223942277954e-05
GSUM3_62 0 n80 n64 0 -0.0012611812273097618
GSUM3_63 0 n80 n65 0 0.00016163339656739942
GSUM3_64 0 n80 n66 0 -0.0018073856626687756
GSUM3_65 0 n80 n67 0 -0.0028031498478059197
EPCB3 n79 0 n80 0 1
V_PCB4 n81 n82 0
RSUM4 n83 0 1
GSUM4_2 0 n83 n4 0 -0.0040415356638089745
GSUM4_3 0 n83 n5 0 0.0026580770551968644
GSUM4_6 0 n83 n8 0 -0.0031208547530989484
GSUM4_8 0 n83 n10 0 0.00057356243898302247
GSUM4_10 0 n83 n12 0 0.0047471258044043934
GSUM4_14 0 n83 n16 0 0.00219485298518111
GSUM4_18 0 n83 n20 0 -0.0053125984246029266
GSUM4_23 0 n83 n25 0 0.017988656065052941
GSUM4_24 0 n83 n26 0 1.1638105674335338e-05
GSUM4_25 0 n83 n27 0 6.1067249880398181e-06
GSUM4_26 0 n83 n28 0 4.542658158225832e-05
GSUM4_27 0 n83 n29 0 0.0025385435036612627
GSUM4_28 0 n83 n30 0 0.00016916569399025327
GSUM4_29 0 n83 n31 0 1.9787811216744453e-05
GSUM4_30 0 n83 n32 0 0.00085351090741463305
GSUM4_31 0 n83 n33 0 0.00030875773751538958
GSUM4_32 0 n83 n34 0 -0.00063967329829240423
GSUM4_33 0 n83 n35 0 0.0016416898247539476
GSUM4_34 0 n83 n36 0 -0.00081846451551672423
GSUM4_35 0 n83 n37 0 0.0017751561371409355
GSUM4_36 0 n83 n38 0 0.00038485232361118297
GSUM4_37 0 n83 n39 0 5.9787647690355439e-05
GSUM4_38 0 n83 n40 0 0.0003127566298799116
GSUM4_39 0 n83 n41 0 0.0009123589847341518
GSUM4_40 0 n83 n42 0 0.013405812095463598
GSUM4_41 0 n83 n43 0 0.0047699729869881509
GSUM4_42 0 n83 n44 0 0.00022954256590040407
GSUM4_43 0 n83 n45 0 0.0038161695080006397
GSUM4_44 0 n83 n46 0 0.00093618590103750662
GSUM4_45 0 n83 n47 0 2.0777278598553645e-05
GSUM4_46 0 n83 n48 0 0.0032244690236346374
GSUM4_47 0 n83 n49 0 -0.0013548102256586924
GSUM4_48 0 n83 n50 0 -0.0074321156526475553
GSUM4_49 0 n83 n51 0 0.0044663914229746519
GSUM4_50 0 n83 n52 0 0.0017855756865643101
GSUM4_51 0 n83 n53 0 0.0021471244608343783
GSUM4_52 0 n83 n54 0 -0.00036751386901718198
GSUM4_53 0 n83 n55 0 -0.00028531098037509387
GSUM4_54 0 n83 n56 0 0.0059170698333088209
GSUM4_55 0 n83 n57 0 -0.0045071606241683928
GSUM4_56 0 n83 n58 0 -0.0079650712646451103
GSUM4_57 0 n83 n59 0 0.0044017267372596335
GSUM4_58 0 n83 n60 0 0.0013322518907157323
GSUM4_59 0 n83 n61 0 -0.00066976005212447784
GSUM4_60 0 n83 n62 0 -0.0011618929434354835
GSUM4_61 0 n83 n63 0 0.0046683084222985524
GSUM4_62 0 n83 n64 0 -0.010493388458686428
GSUM4_63 0 n83 n65 0 0.00736655641801347
GSUM4_64 0 n83 n66 0 -0.013282526286645415
GSUM4_65 0 n83 n67 0 0.045769668059797958
EPCB4 n82 n72 n83 0 1
V_PCB5 n84 n85 0
RSUM5 n86 0 1
GSUM5_0 0 n86 n2 0 -0.0037726233254458934
GSUM5_1 0 n86 n3 0 -0.00041974718520652367
GSUM5_7 0 n86 n9 0 0.0052044480040197537
GSUM5_9 0 n86 n11 0 0.00039597137629887607
GSUM5_15 0 n86 n17 0 -0.00039536487091820831
GSUM5_17 0 n86 n19 0 0.0065228220594619069
GSUM5_19 0 n86 n21 0 -0.0061875152326659232
GSUM5_24 0 n86 n26 0 7.2305429522684819e-06
GSUM5_25 0 n86 n27 0 1.1626681858490304e-05
GSUM5_26 0 n86 n28 0 -4.4248355786870723e-05
GSUM5_27 0 n86 n29 0 0.0002927488382598487
GSUM5_28 0 n86 n30 0 0.0024069344986944762
GSUM5_29 0 n86 n31 0 -3.0993043695684786e-05
GSUM5_30 0 n86 n32 0 -0.00039042363429998855
GSUM5_31 0 n86 n33 0 -0.00019310556623951871
GSUM5_32 0 n86 n34 0 0.00074524211896248712
GSUM5_33 0 n86 n35 0 0.00028148083669513681
GSUM5_34 0 n86 n36 0 9.6114685360731002e-06
GSUM5_35 0 n86 n37 0 -0.00030571703736325257
GSUM5_36 0 n86 n38 0 -4.7232071230703645e-05
GSUM5_37 0 n86 n39 0 -9.4806615659338343e-05
GSUM5_38 0 n86 n40 0 0.00037939686045460253
GSUM5_39 0 n86 n41 0 2.316363960972856e-06
GSUM5_40 0 n86 n42 0 0.0001013995242725579
GSUM5_41 0 n86 n43 0 -6.0787135374563765e-05
GSUM5_42 0 n86 n44 0 -0.00018367063985388801
GSUM5_43 0 n86 n45 0 0.0020936809502917963
GSUM5_44 0 n86 n46 0 -0.0034107666625414201
GSUM5_45 0 n86 n47 0 0.0007865960571746645
GSUM5_46 0 n86 n48 0 -0.0029129692187766679
GSUM5_47 0 n86 n49 0 -0.00042350111745045492
GSUM5_48 0 n86 n50 0 -0.0049468586753258883
GSUM5_49 0 n86 n51 0 -0.00055063808727737976
GSUM5_50 0 n86 n52 0 -0.0022236142618012387
GSUM5_51 0 n86 n53 0 0.0042547697417789467
GSUM5_52 0 n86 n54 0 -0.0025147098292209696
GSUM5_53 0 n86 n55 0 -0.0011783415901467449
GSUM5_54 0 n86 n56 0 -0.0006609247654757491
GSUM5_55 0 n86 n57 0 -0.00020158383619176036
GSUM5_56 0 n86 n58 0 0.002127946870277011
GSUM5_57 0 n86 n59 0 -0.0015611707444481797
GSUM5_58 0 n86 n60 0 -0.0043552751200280852
GSUM5_59 0 n86 n61 0 0.0025861906416565186
GSUM5_60 0 n86 n62 0 0.0023199728108747476
GSUM5_61 0 n86 n63 0 0.00012750910272340686
GSUM5_62 0 n86 n64 0 -0.0026354805188486099
GSUM5_63 0 n86 n65 0 0.00061225322890272706
GSUM5_64 0 n86 n66 0 -0.0038772429481399155
GSUM5_65 0 n86 n67 0 -0.0031860060102346715
EPCB5 n85 0 n86 0 1
V_PCB6 n87 n88 0
RSUM6 n89 0 1
GSUM6_2 0 n89 n4 0 0.0040240992368930839
GSUM6_3 0 n89 n5 0 0.0027664287441775642
GSUM6_6 0 n89 n8 0 0.0026817304083229443
GSUM6_8 0 n89 n10 0 0.0027809965489992081
GSUM6_10 0 n89 n12 0 0.0043213923721710382
GSUM6_14 0 n89 n16 0 0.0032193297129322878
GSUM6_18 0 n89 n20 0 -0.00023651541348260796
GSUM6_23 0 n89 n25 0 0.020743987600289306
GSUM6_24 0 n89 n26 0 -3.326954993692481e-06
GSUM6_25 0 n89 n27 0 -9.5595091727012496e-06
GSUM6_26 0 n89 n28 0 0.00051460547781130876
GSUM6_27 0 n89 n29 0 0.0028442353720935709
GSUM6_28 0 n89 n30 0 -0.00032970774547806946
GSUM6_29 0 n89 n31 0 4.2313058016993553e-05
GSUM6_30 0 n89 n32 0 0.00030441258830548766
GSUM6_31 0 n89 n33 0 -0.00024945857406800595
GSUM6_32 0 n89 n34 0 0.0001305428048331769
GSUM6_33 0 n89 n35 0 0.0016917065122439836
GSUM6_34 0 n89 n36 0 0.00044238873122838475
GSUM6_35 0 n89 n37 0 2.5612797683000075e-05
GSUM6_36 0 n89 n38 0 0.00019420736910544261
GSUM6_37 0 n89 n39 0 1.9276922530003377e-05
GSUM6_38 0 n89 n40 0 0.00043350218405461779
GSUM6_39 0 n89 n41 0 0.00098168748005804753
GSUM6_40 0 n89 n42 0 0.014234810010235324
GSUM6_41 0 n89 n43 0 0.0049528178651904019
GSUM6_42 0 n89 n44 0 2.3936840642884041e-05
GSUM6_43 0 n89 n45 0 0.0050209078562469941
GSUM6_44 0 n89 n46 0 0.00057980714475948999
GSUM6_45 0 n89 n47 0 0.00026322323497270594
GSUM6_46 0 n89 n48 0 0.0028919575791202922
GSUM6_47 0 n89 n49 0 -0.0016282487597120351
GSUM6_48 0 n89 n50 0 -0.0093428805472947872
GSUM6_49 0 n89 n51 0 0.0044788277826825745
GSUM6_50 0 n89 n52 0 -0.0014003301103771605
GSUM6_51 0 n89 n53 0 4.4571523005062778e-05
GSUM6_52 0 n89 n54 0 -0.00067721673756325799
GSUM6_53 0 n89 n55 0 -0.00040081122111931903
GSUM6_54 0 n89 n56 0 0.0062437670575292269
GSUM6_55 0 n89 n57 0 -0.0052113580498192522
GSUM6_56 0 n89 n58 0 -0.0085089790329548037
GSUM6_57 0 n89 n59 0 0.0044175814034721353
GSUM6_58 0 n89 n60 0 0.001039856488995315
GSUM6_59 0 n89 n61 0 -0.00050784182938517065
GSUM6_60 0 n89 n62 0 -0.0011666832940738824
GSUM6_61 0 n89 n63 0 0.0052342322416051388
GSUM6_62 0 n89 n64 0 -0.011999339850005914
GSUM6_63 0 n89 n65 0 0.0080686421913021191
GSUM6_64 0 n89 n66 0 -0.015925038645556475
GSUM6_65 0 n89 n67 0 0.051128855085227173
EPCB6 n88 n72 n89 0 1
V_PCB7 n90 n91 0
RSUM7 n92 0 1
GSUM7_0 0 n92 n2 0 0.0022343453738755295
GSUM7_1 0 n92 n3 0 0.0044597809480207235
GSUM7_7 0 n92 n9 0 0.0024250500575711395
GSUM7_9 0 n92 n11 0 -0.00022116089195756226
GSUM7_15 0 n92 n17 0 -0.00042476628335577995
GSUM7_17 0 n92 n19 0 0.0085054856564015582
GSUM7_19 0 n92 n21 0 -0.0077403219707197048
GSUM7_24 0 n92 n26 0 7.7353177298950518e-06
GSUM7_25 0 n92 n27 0 8.0692172809862976e-06
GSUM7_26 0 n92 n28 0 -4.2295898769973959e-05
GSUM7_27 0 n92 n29 0 0.0002787606047494175
GSUM7_28 0 n92 n30 0 0.0033218133060931997
GSUM7_29 0 n92 n31 0 -5.5164561705611747e-05
GSUM7_30 0 n92 n32 0 -0.00054073608176732825
GSUM7_31 0 n92 n33 0 -0.00025914984016785019
GSUM7_32 0 n92 n34 0 0.0010649023733131039
GSUM7_33 0 n92 n35 0 0.00039883308060325158
GSUM7_34 0 n92 n36 0 2.1504268186472795e-05
GSUM7_35 0 n92 n37 0 -0.00045902689327898574
GSUM7_36 0 n92 n38 0 -7.679369678693854e-05
GSUM7_37 0 n92 n39 0 -0.00015403861800952792
GSUM7_38 0 n92 n40 0 0.00052794238046273369
GSUM7_39 0 n92 n41 0 -1.3743994819158105e-05
GSUM7_40 0 n92 n42 0 0.00013038546782493491
GSUM7_41 0 n92 n43 0 -8.8489760039601445e-05
GSUM7_42 0 n92 n44 0 -0.0002173717550779173
GSUM7_43 0 n92 n45 0 0.0031491019218210271
GSUM7_44 0 n92 n46 0 -0.0046429013901875807
GSUM7_45 0 n92 n47 0 0.00098531853745549721
GSUM7_46 0 n92 n48 0 -0.0049446050359977988
GSUM7_47 0 n92 n49 0 -0.0004555293394303948
GSUM7_48 0 n92 n50 0 -0.0069362210131527907
GSUM7_49 0 n92 n51 0 -0.00135129256461695
GSUM7_50 0 n92 n52 0 -0.0027833519537450446
GSUM7_51 0 n92 n53 0 0.0049675670962378727
GSUM7_52 0 n92 n54 0 -0.0031398178773711363
GSUM7_53 0 n92 n55 0 -0.0014409577382662139
GSUM7_54 0 n92 n56 0 -0.0010728311185645033
GSUM7_55 0 n92 n57 0 -0.0001343254320204627
GSUM7_56 0 n92 n58 0 0.0029735220903143651
GSUM7_57 0 n92 n59 0 -0.0021629681441898618
GSUM7_58 0 n92 n60 0 -0.0058632892076554708
GSUM7_59 0 n92 n61 0 0.0031525823029595035
GSUM7_60 0 n92 n62 0 0.0027902692683029946
GSUM7_61 0 n92 n63 0 0.00021809189995056883
GSUM7_62 0 n92 n64 0 -0.0038041815457289184
GSUM7_63 0 n92 n65 0 0.0010473955251607547
GSUM7_64 0 n92 n66 0 -0.0054607917307795267
GSUM7_65 0 n92 n67 0 -0.0035212026861213214
EPCB7 n91 0 n92 0 1
V_PCB8 n93 n94 0
RSUM8 n95 0 1
GSUM8_2 0 n95 n4 0 -0.0023134874725188395
GSUM8_3 0 n95 n5 0 -0.0044390048776590174
GSUM8_6 0 n95 n8 0 0.0045196727533137748
GSUM8_8 0 n95 n10 0 0.0021753070631927254
GSUM8_10 0 n95 n12 0 0.0017176342354977875
GSUM8_14 0 n95 n16 0 0.00058250095163253938
GSUM8_18 0 n95 n20 0 0.0046377988497402706
GSUM8_23 0 n95 n25 0 0.022607444046756454
GSUM8_24 0 n95 n26 0 -1.9378059584432809e-05
GSUM8_25 0 n95 n27 0 -2.2361074784222195e-05
GSUM8_26 0 n95 n28 0 0.00058943690236055372
GSUM8_27 0 n95 n29 0 0.0014698255529856743
GSUM8_28 0 n95 n30 0 -0.00073784351881036334
GSUM8_29 0 n95 n31 0 5.2856538995528707e-05
GSUM8_30 0 n95 n32 0 -0.00036881536870691936
GSUM8_31 0 n95 n33 0 -0.00078407466676727383
GSUM8_32 0 n95 n34 0 0.00098616017836882734
GSUM8_33 0 n95 n35 0 0.0017250684434252841
GSUM8_34 0 n95 n36 0 0.0014995353622436214
GSUM8_35 0 n95 n37 0 -0.0015140793848558059
GSUM8_36 0 n95 n38 0 1.0564177851990501e-05
GSUM8_37 0 n95 n39 0 -3.6317889983941996e-05
GSUM8_38 0 n95 n40 0 0.00058552420206043601
GSUM8_39 0 n95 n41 0 0.00099691563710521246
GSUM8_40 0 n95 n42 0 0.014781953975340038
GSUM8_41 0 n95 n43 0 0.0050482924259588093
GSUM8_42 0 n95 n44 0 -0.00016884956908776546
GSUM8_43 0 n95 n45 0 0.0060993361986890057
GSUM8_44 0 n95 n46 0 0.0003667289893260514
GSUM8_45 0 n95 n47 0 0.00031836815714931849
GSUM8_46 0 n95 n48 0 0.0021980094094263057
GSUM8_47 0 n95 n49 0 -0.0018417761831100116
GSUM8_48 0 n95 n50 0 -0.010736280641136343
GSUM8_49 0 n95 n51 0 0.0042510045771365504
GSUM8_50 0 n95 n52 0 -0.0032362421382668874
GSUM8_51 0 n95 n53 0 -0.0016087423543031177
GSUM8_52 0 n95 n54 0 -0.0008560568654959593
GSUM8_53 0 n95 n55 0 -0.00041744926549920847
GSUM8_54 0 n95 n56 0 0.006285655226083528
GSUM8_55 0 n95 n57 0 -0.0056091272601913765
GSUM8_56 0 n95 n58 0 -0.0086167018806184974
GSUM8_57 0 n95 n59 0 0.0043255163859788979
GSUM8_58 0 n95 n60 0 0.00055325464235169276
GSUM8_59 0 n95 n61 0 -0.00037492559159477937
GSUM8_60 0 n95 n62 0 -0.0011689103886516937
GSUM8_61 0 n95 n63 0 0.0055362498773142404
GSUM8_62 0 n95 n64 0 -0.013092906190965098
GSUM8_63 0 n95 n65 0 0.0086231911674862927
GSUM8_64 0 n95 n66 0 -0.017770941576756599
GSUM8_65 0 n95 n67 0 0.053735754722664557
EPCB8 n94 n72 n95 0 1
V_PCB9 n96 n97 0
RSUM9 n98 0 1
GSUM9_0 0 n98 n2 0 -0.00041283436754460602
GSUM9_1 0 n98 n3 0 -0.0016562916445198249
GSUM9_7 0 n98 n9 0 -0.0063609752728004841
GSUM9_9 0 n98 n11 0 -0.0015437795627481865
GSUM9_15 0 n98 n17 0 -0.00050505462750670622
GSUM9_17 0 n98 n19 0 0.011214938476458032
GSUM9_19 0 n98 n21 0 -0.0092439080546027098
GSUM9_24 0 n98 n26 0 6.2528422228038907e-06
GSUM9_25 0 n98 n27 0 -4.7576937825267626e-05
GSUM9_26 0 n98 n28 0 -0.00025828411193481716
GSUM9_27 0 n98 n29 0 0.00013321502604985696
GSUM9_28 0 n98 n30 0 0.0061691525411871548
GSUM9_29 0 n98 n31 0 -9.9620241717097305e-05
GSUM9_30 0 n98 n32 0 -0.0011126072670906977
GSUM9_31 0 n98 n33 0 -0.00047551889627859087
GSUM9_32 0 n98 n34 0 0.0020552385422378406
GSUM9_33 0 n98 n35 0 0.00073024079689655292
GSUM9_34 0 n98 n36 0 2.7165711786328078e-05
GSUM9_35 0 n98 n37 0 -0.00098205994436477147
GSUM9_36 0 n98 n38 0 -0.00022648343287609281
GSUM9_37 0 n98 n39 0 -0.0003013854621770077
GSUM9_38 0 n98 n40 0 0.0010864074811087372
GSUM9_39 0 n98 n41 0 -0.00010696747056613361
GSUM9_40 0 n98 n42 0 0.00025795266804167329
GSUM9_41 0 n98 n43 0 -0.00020610051737706626
GSUM9_42 0 n98 n44 0 -0.00042541155725352652
GSUM9_43 0 n98 n45 0 0.0041981927396363408
GSUM9_44 0 n98 n46 0 -0.0050474835567354444
GSUM9_45 0 n98 n47 0 0.0010102459344496786
GSUM9_46 0 n98 n48 0 -0.0068737032190878218
GSUM9_47 0 n98 n49 0 -0.00022758646792442056
GSUM9_48 0 n98 n50 0 -0.008630999233902821
GSUM9_49 0 n98 n51 0 -0.0024580785954848162
GSUM9_50 0 n98 n52 0 -0.0030593131808669427
GSUM9_51 0 n98 n53 0 0.0044877170789564087
GSUM9_52 0 n98 n54 0 -0.0026403907942836318
GSUM9_53 0 n98 n55 0 -0.0011199292632999127
GSUM9_54 0 n98 n56 0 -0.00037738330187045649
GSUM9_55 0 n98 n57 0 2.1325261298067266e-05
GSUM9_56 0 n98 n58 0 0.0040767862414124185
GSUM9_57 0 n98 n59 0 -0.003016214828774383
GSUM9_58 0 n98 n60 0 -0.0090477095104501727
GSUM9_59 0 n98 n61 0 0.0039217407945680632
GSUM9_60 0 n98 n62 0 0.0038198453512807177
GSUM9_61 0 n98 n63 0 0.00018200140859362014
GSUM9_62 0 n98 n64 0 -0.0053855121290048834
GSUM9_63 0 n98 n65 0 0.0013613830428865037
GSUM9_64 0 n98 n66 0 -0.0058071150980178784
GSUM9_65 0 n98 n67 0 -0.0030602161269870699
EPCB9 n97 0 n98 0 1
V_PCB10 n99 n100 0
RSUM10 n101 0 1
GSUM10_2 0 n101 n4 0 0.00047160900338077478
GSUM10_3 0 n101 n5 0 0.0013408018974613051
GSUM10_6 0 n101 n8 0 -0.0021419056138338726
GSUM10_8 0 n101 n10 0 -0.0032756227768154541
GSUM10_10 0 n101 n12 0 0.00033047044751104143
GSUM10_14 0 n101 n16 0 -0.0076236331523425087
GSUM10_18 0 n101 n20 0 0.009917688432541585
GSUM10_23 0 n101 n25 0 0.024131523898767809
GSUM10_24 0 n101 n26 0 -3.2026980679488348e-05
GSUM10_25 0 n101 n27 0 -4.7716138675895245e-05
GSUM10_26 0 n101 n28 0 -0.00038637604562625919
GSUM10_27 0 n101 n29 0 -0.0034007970487156471
GSUM10_28 0 n101 n30 0 -0.0014906679468257036
GSUM10_29 0 n101 n31 0 0.0001329160180778221
GSUM10_30 0 n101 n32 0 -0.0021205686125472258
GSUM10_31 0 n101 n33 0 -0.0019355701783788529
GSUM10_32 0 n101 n34 0 0.0031992759936543378
GSUM10_33 0 n101 n35 0 0.0029473071632608022
GSUM10_34 0 n101 n36 0 0.002706648525695788
GSUM10_35 0 n101 n37 0 -0.0032164079758079884
GSUM10_36 0 n101 n38 0 -0.00019379637729735974
GSUM10_37 0 n101 n39 0 -0.00011669766983648588
GSUM10_38 0 n101 n40 0 0.00064468079520421087
GSUM10_39 0 n101 n41 0 0.00066122124014467143
GSUM10_40 0 n101 n42 0 0.015303257051133551
GSUM10_41 0 n101 n43 0 0.0051627606867259571
GSUM10_42 0 n101 n44 0 -0.00015562183083984462
GSUM10_43 0 n101 n45 0 0.0073230358617780572
GSUM10_44 0 n101 n46 0 7.8792756621768955e-05
GSUM10_45 0 n101 n47 0 0.00014497558526301854
GSUM10_46 0 n101 n48 0 0.0011311028586977652
GSUM10_47 0 n101 n49 0 -0.0021956085603100362
GSUM10_48 0 n101 n50 0 -0.011927392784357237
GSUM10_49 0 n101 n51 0 0.004391949353177986
GSUM10_50 0 n101 n52 0 -0.0036825999180019652
GSUM10_51 0 n101 n53 0 -0.0021038373777655297
GSUM10_52 0 n101 n54 0 -0.001183392370689123
GSUM10_53 0 n101 n55 0 -0.00019982230997156908
GSUM10_54 0 n101 n56 0 0.0058212469221797852
GSUM10_55 0 n101 n57 0 -0.0052664069686410939
GSUM10_56 0 n101 n58 0 -0.0086091737172396248
GSUM10_57 0 n101 n59 0 0.0041306841315369965
GSUM10_58 0 n101 n60 0 -0.00046747296177957181
GSUM10_59 0 n101 n61 0 9.7184819943886533e-06
GSUM10_60 0 n101 n62 0 -0.00068969260084010846
GSUM10_61 0 n101 n63 0 0.0057819637718652889
GSUM10_62 0 n101 n64 0 -0.014340432369385163
GSUM10_63 0 n101 n65 0 0.0091835021641813626
GSUM10_64 0 n101 n66 0 -0.017713287081438323
GSUM10_65 0 n101 n67 0 0.054010200135277686
EPCB10 n100 n72 n101 0 1
V_PCB11 n102 n104 0
RSUM11 n105 0 1
GSUM11_4 0 n105 n6 0 0.0029203109458699845
GSUM11_12 0 n105 n14 0 -0.007144120130209511
GSUM11_20 0 n105 n22 0 0.023369386662932742
GSUM11_24 0 n105 n26 0 -0.0014773901708698748
GSUM11_25 0 n105 n27 0 0.001392252369015504
GSUM11_26 0 n105 n28 0 2.4345009514542483e-05
GSUM11_27 0 n105 n29 0 4.719536761699934e-05
GSUM11_28 0 n105 n30 0 -0.00026208450347779368
GSUM11_29 0 n105 n31 0 -0.0048508955181598206
GSUM11_30 0 n105 n32 0 1.4623277239099362e-05
GSUM11_31 0 n105 n33 0 0.0015921859071580703
GSUM11_32 0 n105 n34 0 0.0010505743138716761
GSUM11_33 0 n105 n35 0 0.00011261989953672558
GSUM11_34 0 n105 n36 0 6.2221602253770942e-05
GSUM11_35 0 n105 n37 0 4.7377738796079385e-05
GSUM11_36 0 n105 n38 0 -6.7628877666550178e-05
GSUM11_37 0 n105 n39 0 -0.016748140119407597
GSUM11_38 0 n105 n40 0 -0.0036806823624050333
GSUM11_39 0 n105 n41 0 -0.00013251793664726243
GSUM11_40 0 n105 n42 0 -7.3461938402452498e-05
GSUM11_41 0 n105 n43 0 0.0010455821921422932
GSUM11_42 0 n105 n44 0 0.0044106351068154935
GSUM11_43 0 n105 n45 0 -0.00013687282742944035
GSUM11_44 0 n105 n46 0 0.0040490314414149235
GSUM11_45 0 n105 n47 0 0.0061918514023309602
GSUM11_46 0 n105 n48 0 -0.0075534884711107612
GSUM11_47 0 n105 n49 0 -0.0030039904246493103
GSUM11_48 0 n105 n50 0 -0.00025963369715767501
GSUM11_49 0 n105 n51 0 0.0066624186271408261
GSUM11_50 0 n105 n52 0 0.00024881315663863502
GSUM11_51 0 n105 n53 0 0.00027442899400061869
GSUM11_52 0 n105 n54 0 -0.00035122333558479168
GSUM11_53 0 n105 n55 0 0.011955813345702922
GSUM11_54 0 n105 n56 0 0.0017027881155073433
GSUM11_55 0 n105 n57 0 0.0005304984323370839
GSUM11_56 0 n105 n58 0 0.001403426031845854
GSUM11_57 0 n105 n59 0 -0.00080345444801335764
GSUM11_58 0 n105 n60 0 0.0021405662180594216
GSUM11_59 0 n105 n61 0 0.014832947986289945
GSUM11_60 0 n105 n62 0 -0.0065216694640727376
GSUM11_61 0 n105 n63 0 0.0016368921251192117
GSUM11_62 0 n105 n64 0 0.0011815508272563612
GSUM11_63 0 n105 n65 0 0.0023352042028897562
GSUM11_64 0 n105 n66 0 0.0077460759665247984
GSUM11_65 0 n105 n67 0 0.014129795573521977
EPCB11 n104 n103 n105 0 1
V_PCB12 n106 n108 0
RSUM12 n109 0 1
GSUM12_5 0 n109 n7 0 -0.003266185653719075
GSUM12_13 0 n109 n15 0 -0.0026454015910869389
GSUM12_16 0 n109 n18 0 -0.010710086502184361
GSUM12_22 0 n109 n24 0 0.02907277682204782
GSUM12_24 0 n109 n26 0 0.0014623640211907864
GSUM12_25 0 n109 n27 0 0.0016944612416009768
GSUM12_26 0 n109 n28 0 1.582609212059849e-05
GSUM12_27 0 n109 n29 0 7.5552904779311285e-05
GSUM12_28 0 n109 n30 0 -0.00047897555909733172
GSUM12_29 0 n109 n31 0 0.0019688008677565929
GSUM12_30 0 n109 n32 0 0.00033658579949808712
GSUM12_31 0 n109 n33 0 0.0048839743392632539
GSUM12_32 0 n109 n34 0 0.0028269476054528313
GSUM12_33 0 n109 n35 0 0.00025021511724784352
GSUM12_34 0 n109 n36 0 -0.0017881676286159668
GSUM12_35 0 n109 n37 0 -0.0017098849122742534
GSUM12_36 0 n109 n38 0 0.00086674701314311264
GSUM12_37 0 n109 n39 0 -0.00044291469911283342
GSUM12_38 0 n109 n40 0 0.0013128115014877794
GSUM12_39 0 n109 n41 0 -0.021456826860686767
GSUM12_40 0 n109 n42 0 0.0014045718348715049
GSUM12_41 0 n109 n43 0 0.0013895716382358427
GSUM12_42 0 n109 n44 0 -4.4337888118587847e-05
GSUM12_43 0 n109 n45 0 0.0027796946785295976
GSUM12_44 0 n109 n46 0 0.0016922896658382333
GSUM12_45 0 n109 n47 0 -0.0078168531051848594
GSUM12_46 0 n109 n48 0 -0.0053184857922891722
GSUM12_47 0 n109 n49 0 -0.00028717668464958539
GSUM12_48 0 n109 n50 0 -0.002791630715233672
GSUM12_49 0 n109 n51 0 0.0010774555570176763
GSUM12_50 0 n109 n52 0 0.000838688549958538
GSUM12_51 0 n109 n53 0 -0.00073929977836275946
GSUM12_52 0 n109 n54 0 -0.00050966281020115305
GSUM12_53 0 n109 n55 0 -0.0011194350557332971
GSUM12_54 0 n109 n56 0 0.0081846627334074568
GSUM12_55 0 n109 n57 0 0.016302866266779504
GSUM12_56 0 n109 n58 0 -0.0026693558018874505
GSUM12_57 0 n109 n59 0 -0.001363944926736206
GSUM12_58 0 n109 n60 0 0.00015683648504537652
GSUM12_59 0 n109 n61 0 0.0015697786183355438
GSUM12_60 0 n109 n62 0 -0.001469251710355095
GSUM12_61 0 n109 n63 0 -0.019681068357438387
GSUM12_62 0 n109 n64 0 -0.0069227680182843386
GSUM12_63 0 n109 n65 0 0.0056000020766167309
GSUM12_64 0 n109 n66 0 0.074467957671885618
GSUM12_65 0 n109 n67 0 0.0068978905741580695
EPCB12 n108 n107 n109 0 1
V_PCB13 n110 n111 0
RSUM13 n112 0 1
GSUM13_4 0 n112 n6 0 -0.0063921696331877432
GSUM13_12 0 n112 n14 0 0.0033765896258442763
GSUM13_20 0 n112 n22 0 0.019034151432913558
GSUM13_24 0 n112 n26 0 0.0031291460645184758
GSUM13_25 0 n112 n27 0 -0.0029147274260537615
GSUM13_26 0 n112 n28 0 -3.3397169627252144e-05
GSUM13_27 0 n112 n29 0 -4.1137383926523429e-06
GSUM13_28 0 n112 n30 0 2.2681404107211532e-05
GSUM13_29 0 n112 n31 0 0.0013466950007458695
GSUM13_30 0 n112 n32 0 1.8956104885071287e-05
GSUM13_31 0 n112 n33 0 -0.00056992502934583673
GSUM13_32 0 n112 n34 0 -0.00041074877202252198
GSUM13_33 0 n112 n35 0 -4.5944435041410386e-05
GSUM13_34 0 n112 n36 0 -5.3222214038784289e-05
GSUM13_35 0 n112 n37 0 4.8385242543299984e-05
GSUM13_36 0 n112 n38 0 -0.00024658485071065079
GSUM13_37 0 n112 n39 0 -0.01462791850750716
GSUM13_38 0 n112 n40 0 -0.002886642574830971
GSUM13_39 0 n112 n41 0 -0.00023354043782809755
GSUM13_40 0 n112 n42 0 -4.6504199095060331e-05
GSUM13_41 0 n112 n43 0 0.00079101634525569119
GSUM13_42 0 n112 n44 0 0.0031207870984452362
GSUM13_43 0 n112 n45 0 -0.00028495940268306961
GSUM13_44 0 n112 n46 0 0.0042243324886964244
GSUM13_45 0 n112 n47 0 0.0050441104249725954
GSUM13_46 0 n112 n48 0 -0.0056040722405799456
GSUM13_47 0 n112 n49 0 -0.0018807410089717105
GSUM13_48 0 n112 n50 0 -0.000184609507711168
GSUM13_49 0 n112 n51 0 0.0042839113099416492
GSUM13_50 0 n112 n52 0 -0.00062907275634173484
GSUM13_51 0 n112 n53 0 0.00081016757616605734
GSUM13_52 0 n112 n54 0 -0.00019581604917939363
GSUM13_53 0 n112 n55 0 0.01088428632506697
GSUM13_54 0 n112 n56 0 0.0018849684369691578
GSUM13_55 0 n112 n57 0 0.0010743702164043389
GSUM13_56 0 n112 n58 0 0.00095728168645622133
GSUM13_57 0 n112 n59 0 -0.00053079880067983176
GSUM13_58 0 n112 n60 0 0.0016593674729358705
GSUM13_59 0 n112 n61 0 0.011428089875326149
GSUM13_60 0 n112 n62 0 -0.0045540628705447962
GSUM13_61 0 n112 n63 0 0.0013590692225646419
GSUM13_62 0 n112 n64 0 0.00085108525113340597
GSUM13_63 0 n112 n65 0 0.0015068554465990926
GSUM13_64 0 n112 n66 0 0.0061103769827907592
GSUM13_65 0 n112 n67 0 0.0094253115276867923
EPCB13 n111 n103 n112 0 1
V_PCB14 n113 n114 0
RSUM14 n115 0 1
GSUM14_5 0 n115 n7 0 0.0073326308161101974
GSUM14_13 0 n115 n15 0 0.0016319806675474376
GSUM14_16 0 n115 n18 0 -0.00028165560741671774
GSUM14_22 0 n115 n24 0 0.026436425537246906
GSUM14_24 0 n115 n26 0 -0.0029557509060270247
GSUM14_25 0 n115 n27 0 -0.0033679522101690835
GSUM14_26 0 n115 n28 0 -2.9131635157980742e-05
GSUM14_27 0 n115 n29 0 6.0678643011024408e-05
GSUM14_28 0 n115 n30 0 -5.3024571721851677e-05
GSUM14_29 0 n115 n31 0 -5.5758976113127207e-05
GSUM14_30 0 n115 n32 0 7.0136592723962231e-05
GSUM14_31 0 n115 n33 0 -9.0749498501917556e-05
GSUM14_32 0 n115 n34 0 -0.00022788980628048503
GSUM14_33 0 n115 n35 0 -6.9063983321611337e-05
GSUM14_34 0 n115 n36 0 -0.0010444191085828157
GSUM14_35 0 n115 n37 0 -0.00081792432365190393
GSUM14_36 0 n115 n38 0 0.00019859036394646295
GSUM14_37 0 n115 n39 0 -0.00028124671450534126
GSUM14_38 0 n115 n40 0 0.0022062480953280467
GSUM14_39 0 n115 n41 0 -0.020915648322367846
GSUM14_40 0 n115 n42 0 0.0013600029985615305
GSUM14_41 0 n115 n43 0 0.00097730957476846111
GSUM14_42 0 n115 n44 0 -0.0010932500972358973
GSUM14_43 0 n115 n45 0 0.0025895702470137452
GSUM14_44 0 n115 n46 0 0.0023774678258444773
GSUM14_45 0 n115 n47 0 -0.0072303123847358517
GSUM14_46 0 n115 n48 0 -0.0041745414541065643
GSUM14_47 0 n115 n49 0 0.0003746561940276858
GSUM14_48 0 n115 n50 0 -0.0027011050588255799
GSUM14_49 0 n115 n51 0 -0.0004994571056185054
GSUM14_50 0 n115 n52 0 0.0001439535451198175
GSUM14_51 0 n115 n53 0 -0.00011321750074253326
GSUM14_52 0 n115 n54 0 -3.9243962954484831e-05
GSUM14_53 0 n115 n55 0 -0.00051490483632461617
GSUM14_54 0 n115 n56 0 0.007561058863583668
GSUM14_55 0 n115 n57 0 0.015123644253257636
GSUM14_56 0 n115 n58 0 -0.0025029406615013992
GSUM14_57 0 n115 n59 0 -0.0011473282336573842
GSUM14_58 0 n115 n60 0 0.000361160907360543
GSUM14_59 0 n115 n61 0 0.00064520624645969288
GSUM14_60 0 n115 n62 0 0.00037547646326175889
GSUM14_61 0 n115 n63 0 -0.019374011463690735
GSUM14_62 0 n115 n64 0 -0.0069981754555458672
GSUM14_63 0 n115 n65 0 0.0046448882511114214
GSUM14_64 0 n115 n66 0 0.067934912718299753
GSUM14_65 0 n115 n67 0 0.0023580213279069499
EPCB14 n114 n107 n115 0 1
V_PCB15 n116 n117 0
RSUM15 n118 0 1
GSUM15_4 0 n118 n6 0 0.0046993685845590624
GSUM15_12 0 n118 n14 0 0.0090324444914554689
GSUM15_20 0 n118 n22 0 0.011368261108199326
GSUM15_24 0 n118 n26 0 -0.0019566843817067593
GSUM15_25 0 n118 n27 0 0.0018878747686670596
GSUM15_26 0 n118 n28 0 1.0924437829091576e-05
GSUM15_27 0 n118 n29 0 -5.1614438691247456e-05
GSUM15_28 0 n118 n30 0 0.00031400619748376738
GSUM15_29 0 n118 n31 0 0.005728524983473233
GSUM15_30 0 n118 n32 0 -5.4036927096788244e-05
GSUM15_31 0 n118 n33 0 -0.0021325089844871905
GSUM15_32 0 n118 n34 0 -0.0014188678731391622
GSUM15_33 0 n118 n35 0 -0.00012411196656817312
GSUM15_34 0 n118 n36 0 -7.3257959907605137e-05
GSUM15_35 0 n118 n37 0 8.9670837651045898e-05
GSUM15_36 0 n118 n38 0 -0.00029941658640811043
GSUM15_37 0 n118 n39 0 -0.010495443742662657
GSUM15_38 0 n118 n40 0 -0.0019055885381396365
GSUM15_39 0 n118 n41 0 -0.0002193154253108835
GSUM15_40 0 n118 n42 0 -3.2491222705565162e-05
GSUM15_41 0 n118 n43 0 0.0005034218162229435
GSUM15_42 0 n118 n44 0 0.0016947206150552542
GSUM15_43 0 n118 n45 0 -0.00031202151085125371
GSUM15_44 0 n118 n46 0 0.0027121094858787637
GSUM15_45 0 n118 n47 0 0.0029919148142454103
GSUM15_46 0 n118 n48 0 -0.0028354709813247477
GSUM15_47 0 n118 n49 0 -0.00085926575535989985
GSUM15_48 0 n118 n50 0 -3.0756605340857825e-05
GSUM15_49 0 n118 n51 0 0.001915546468583741
GSUM15_50 0 n118 n52 0 -0.0012948671923518553
GSUM15_51 0 n118 n53 0 0.0011762278105849186
GSUM15_52 0 n118 n54 0 -3.467654813898922e-05
GSUM15_53 0 n118 n55 0 0.0068740914195801047
GSUM15_54 0 n118 n56 0 0.001328400174568093
GSUM15_55 0 n118 n57 0 0.0008630577223169366
GSUM15_56 0 n118 n58 0 0.0004529949614287275
GSUM15_57 0 n118 n59 0 -0.00016934199887969604
GSUM15_58 0 n118 n60 0 0.001085266339535594
GSUM15_59 0 n118 n61 0 0.0059975558651853347
GSUM15_60 0 n118 n62 0 -0.0021844137733542305
GSUM15_61 0 n118 n63 0 0.00073883028013663145
GSUM15_62 0 n118 n64 0 0.00049364211663090825
GSUM15_63 0 n118 n65 0 0.00062714234160126531
GSUM15_64 0 n118 n66 0 0.0020063085910398933
GSUM15_65 0 n118 n67 0 0.005158726593445559
EPCB15 n117 n103 n118 0 1
V_PCB16 n119 n120 0
RSUM16 n121 0 1
GSUM16_5 0 n121 n7 0 -0.0036355026013978591
GSUM16_13 0 n121 n15 0 0.0070188519201702555
GSUM16_16 0 n121 n18 0 0.0079487130200660266
GSUM16_22 0 n121 n24 0 0.025301538915791153
GSUM16_24 0 n121 n26 0 0.0014640785054038253
GSUM16_25 0 n121 n27 0 0.00166183109783455
GSUM16_26 0 n121 n28 0 2.7659892797265436e-05
GSUM16_27 0 n121 n29 0 -7.4986468653974301e-05
GSUM16_28 0 n121 n30 0 0.00034360582013281634
GSUM16_29 0 n121 n31 0 -0.0021950154513151665
GSUM16_30 0 n121 n32 0 -0.00036409124942690462
GSUM16_31 0 n121 n33 0 -0.005189646021647825
GSUM16_32 0 n121 n34 0 -0.0031210432415622719
GSUM16_33 0 n121 n35 0 -3.3305780743888743e-05
GSUM16_34 0 n121 n36 0 -0.00042181337736530523
GSUM16_35 0 n121 n37 0 5.8713730506151221e-05
GSUM16_36 0 n121 n38 0 -0.00043303674794456591
GSUM16_37 0 n121 n39 0 0.00021317960234366984
GSUM16_38 0 n121 n40 0 0.0030392504059925389
GSUM16_39 0 n121 n41 0 -0.020586372414634718
GSUM16_40 0 n121 n42 0 0.0013320747754956867
GSUM16_41 0 n121 n43 0 0.00056551232136003396
GSUM16_42 0 n121 n44 0 -0.0023825015838955742
GSUM16_43 0 n121 n45 0 0.0023638699555103594
GSUM16_44 0 n121 n46 0 0.0028134377542585478
GSUM16_45 0 n121 n47 0 -0.0075275626019450188
GSUM16_46 0 n121 n48 0 -0.0030550715374356016
GSUM16_47 0 n121 n49 0 0.00093275497538617737
GSUM16_48 0 n121 n50 0 -0.0026447675443614939
GSUM16_49 0 n121 n51 0 -0.0023342692862296007
GSUM16_50 0 n121 n52 0 -0.0010162786113525628
GSUM16_51 0 n121 n53 0 0.00085668930344426786
GSUM16_52 0 n121 n54 0 0.0004634460417476829
GSUM16_53 0 n121 n55 0 -0.00093149968162547895
GSUM16_54 0 n121 n56 0 0.0070624887453247711
GSUM16_55 0 n121 n57 0 0.014430363861335269
GSUM16_56 0 n121 n58 0 -0.0026633681120887221
GSUM16_57 0 n121 n59 0 -0.00094254440490494369
GSUM16_58 0 n121 n60 0 0.00076209082966634115
GSUM16_59 0 n121 n61 0 -0.00053802207883364012
GSUM16_60 0 n121 n62 0 0.0021976840062479714
GSUM16_61 0 n121 n63 0 -0.01928627049545318
GSUM16_62 0 n121 n64 0 -0.0070683611555225649
GSUM16_63 0 n121 n65 0 0.0037444957583129064
GSUM16_64 0 n121 n66 0 0.062078708736717406
GSUM16_65 0 n121 n67 0 -0.0030202881272366902
EPCB16 n120 n107 n121 0 1
V_PCB17 n122 n124 0
RSUM17 n125 0 1
GSUM17_11 0 n125 n13 0 -0.0081339732062566446
GSUM17_21 0 n125 n23 0 -0.03101942719782266
GSUM17_24 0 n125 n26 0 -3.2861031097034823e-07
GSUM17_25 0 n125 n27 0 1.5049539366584657e-05
GSUM17_26 0 n125 n28 0 -0.00013173722826408869
GSUM17_27 0 n125 n29 0 -3.4532772695527314e-05
GSUM17_28 0 n125 n30 0 -0.00022760790334006321
GSUM17_29 0 n125 n31 0 -1.9432333089336704e-05
GSUM17_30 0 n125 n32 0 0.0043716903646434744
GSUM17_31 0 n125 n33 0 -0.0022705665970642434
GSUM17_32 0 n125 n34 0 0.0033912840926171774
GSUM17_33 0 n125 n35 0 -0.0013180884214066418
GSUM17_34 0 n125 n36 0 -0.00071350334940878076
GSUM17_35 0 n125 n37 0 0.0003661250731057385
GSUM17_36 0 n125 n38 0 -0.00018035387892875168
GSUM17_37 0 n125 n39 0 -0.00024114045946696644
GSUM17_38 0 n125 n40 0 0.0055452945779808551
GSUM17_39 0 n125 n41 0 0.0014260529490881216
GSUM17_40 0 n125 n42 0 -0.0091681984358986512
GSUM17_41 0 n125 n43 0 0.02870146571548347
GSUM17_42 0 n125 n44 0 0.0033031361494470701
GSUM17_43 0 n125 n45 0 0.0048521922998239356
GSUM17_44 0 n125 n46 0 -5.069168340658369e-05
GSUM17_45 0 n125 n47 0 0.00067552570866595486
GSUM17_46 0 n125 n48 0 -0.00064726085520028578
GSUM17_47 0 n125 n49 0 0.01322959363015363
GSUM17_48 0 n125 n50 0 -0.0012703988176640231
GSUM17_49 0 n125 n51 0 0.01048647328672395
GSUM17_50 0 n125 n52 0 -0.00056286198270212638
GSUM17_51 0 n125 n53 0 0.00043320930247027527
GSUM17_52 0 n125 n54 0 7.9174219247917643e-05
GSUM17_53 0 n125 n55 0 -0.00049951218831700318
GSUM17_54 0 n125 n56 0 0.0020638595622403115
GSUM17_55 0 n125 n57 0 0.0013930352503357991
GSUM17_56 0 n125 n58 0 0.012318376841670033
GSUM17_57 0 n125 n59 0 0.025946386253449208
GSUM17_58 0 n125 n60 0 0.00018696990816964134
GSUM17_59 0 n125 n61 0 0.00017598456623766877
GSUM17_60 0 n125 n62 0 0.0076860079039814217
GSUM17_61 0 n125 n63 0 0.00054477441050043555
GSUM17_62 0 n125 n64 0 0.013804352281937604
GSUM17_63 0 n125 n65 0 0.025679397854281825
GSUM17_64 0 n125 n66 0 0.0089490468074329976
GSUM17_65 0 n125 n67 0 0.060369221074060647
EPCB17 n124 n123 n125 0 1
V_PCB18 n126 n127 0
RSUM18 n128 0 1
GSUM18_2 0 n128 n4 0 -6.3255074473726912e-05
GSUM18_3 0 n128 n5 0 0.00041969313831575908
GSUM18_6 0 n128 n8 0 0.003203029714790322
GSUM18_8 0 n128 n10 0 -0.0089266387562395334
GSUM18_10 0 n128 n12 0 -0.0020080530532992783
GSUM18_14 0 n128 n16 0 0.0025122876636326026
GSUM18_18 0 n128 n20 0 -0.0059043390628725273
GSUM18_23 0 n128 n25 0 0.013633234282548392
GSUM18_24 0 n128 n26 0 2.7782039156213238e-07
GSUM18_25 0 n128 n27 0 -1.0510705255795549e-05
GSUM18_26 0 n128 n28 0 0.00014230655927092672
GSUM18_27 0 n128 n29 0 -0.00055390650110564868
GSUM18_28 0 n128 n30 0 -0.00046256202241394718
GSUM18_29 0 n128 n31 0 5.901181532987025e-05
GSUM18_30 0 n128 n32 0 -0.0039564134097410612
GSUM18_31 0 n128 n33 0 -0.00082500901378501081
GSUM18_32 0 n128 n34 0 0.0022390372816425063
GSUM18_33 0 n128 n35 0 -0.0052509207041411673
GSUM18_34 0 n128 n36 0 -0.0043705108122868361
GSUM18_35 0 n128 n37 0 0.0049866212705391598
GSUM18_36 0 n128 n38 0 0.0013065713889938377
GSUM18_37 0 n128 n39 0 -0.00029500102788377187
GSUM18_38 0 n128 n40 0 0.0026414704835316621
GSUM18_39 0 n128 n41 0 0.0013983507781049514
GSUM18_40 0 n128 n42 0 0.0109481110856177
GSUM18_41 0 n128 n43 0 0.0040820734159169253
GSUM18_42 0 n128 n44 0 -0.00097239418551334493
GSUM18_43 0 n128 n45 0 0.0024122273815379808
GSUM18_44 0 n128 n46 0 0.001389987231968999
GSUM18_45 0 n128 n47 0 0.00077193720038047186
GSUM18_46 0 n128 n48 0 0.0025438879447636539
GSUM18_47 0 n128 n49 0 -0.00027847202360704794
GSUM18_48 0 n128 n50 0 -0.0057691885417079551
GSUM18_49 0 n128 n51 0 0.0008249172452672826
GSUM18_50 0 n128 n52 0 0.0042444204731333741
GSUM18_51 0 n128 n53 0 0.0040192869250021464
GSUM18_52 0 n128 n54 0 -0.00016504940821893688
GSUM18_53 0 n128 n55 0 0.00015964327733549135
GSUM18_54 0 n128 n56 0 0.0057824003340548671
GSUM18_55 0 n128 n57 0 -0.004491641064405888
GSUM18_56 0 n128 n58 0 -0.0045412681464980509
GSUM18_57 0 n128 n59 0 0.0038860626646288537
GSUM18_58 0 n128 n60 0 0.0018699182247112129
GSUM18_59 0 n128 n61 0 -0.0011669696463118115
GSUM18_60 0 n128 n62 0 -0.00027698713085550555
GSUM18_61 0 n128 n63 0 0.003276941648532324
GSUM18_62 0 n128 n64 0 -0.0083348944672836552
GSUM18_63 0 n128 n65 0 0.0056993682766466108
GSUM18_64 0 n128 n66 0 -0.013041025177704835
GSUM18_65 0 n128 n67 0 0.036513535177798241
EPCB18 n127 n72 n128 0 1
V_PCB19 n129 n130 0
RSUM19 n131 0 1
GSUM19_2 0 n131 n4 0 5.9395933083366191e-05
GSUM19_3 0 n131 n5 0 0.00036756115320717798
GSUM19_6 0 n131 n8 0 -0.0026101172515261774
GSUM19_8 0 n131 n10 0 0.0022768503628356456
GSUM19_10 0 n131 n12 0 -0.0079873162337580714
GSUM19_14 0 n131 n16 0 0.0058587710470340611
GSUM19_18 0 n131 n20 0 0.0031160105749394409
GSUM19_23 0 n131 n25 0 0.021662543514646838
GSUM19_24 0 n131 n26 0 4.3423771583215954e-05
GSUM19_25 0 n131 n27 0 6.9608990326950194e-05
GSUM19_26 0 n131 n28 0 -0.00010347952046650009
GSUM19_27 0 n131 n29 0 -0.00047150011617115491
GSUM19_28 0 n131 n30 0 0.0010620232634996286
GSUM19_29 0 n131 n31 0 -0.00019852487290945107
GSUM19_30 0 n131 n32 0 0.0015855790386249873
GSUM19_31 0 n131 n33 0 0.0014761936208995379
GSUM19_32 0 n131 n34 0 -0.0026308984756347686
GSUM19_33 0 n131 n35 0 -0.0065908247228782741
GSUM19_34 0 n131 n36 0 0.0022662836438904197
GSUM19_35 0 n131 n37 0 -0.0051949403721225683
GSUM19_36 0 n131 n38 0 -0.00096522425621086902
GSUM19_37 0 n131 n39 0 -0.00039268031420719543
GSUM19_38 0 n131 n40 0 0.0028444462442432888
GSUM19_39 0 n131 n41 0 0.0021593347355681023
GSUM19_40 0 n131 n42 0 0.015223944394350633
GSUM19_41 0 n131 n43 0 0.0044261217245010849
GSUM19_42 0 n131 n44 0 -0.0017241820765383031
GSUM19_43 0 n131 n45 0 0.0058845490922572984
GSUM19_44 0 n131 n46 0 0.00204674315915075
GSUM19_45 0 n131 n47 0 0.00052851809747357268
GSUM19_46 0 n131 n48 0 0.0025351634387568468
GSUM19_47 0 n131 n49 0 -0.00062554298905432041
GSUM19_48 0 n131 n50 0 -0.010742500540378931
GSUM19_49 0 n131 n51 0 0.0016528235799765716
GSUM19_50 0 n131 n52 0 -0.0023630188963247646
GSUM19_51 0 n131 n53 0 -0.0029449649742182976
GSUM19_52 0 n131 n54 0 0.00051547916723625263
GSUM19_53 0 n131 n55 0 0.00029241763191390808
GSUM19_54 0 n131 n56 0 0.0074203411529468006
GSUM19_55 0 n131 n57 0 -0.0065333763975000481
GSUM19_56 0 n131 n58 0 -0.0073049426944405719
GSUM19_57 0 n131 n59 0 0.0042139611108297009
GSUM19_58 0 n131 n60 0 0.00070586453358086477
GSUM19_59 0 n131 n61 0 -0.00058651734311197812
GSUM19_60 0 n131 n62 0 0.00073881511856373368
GSUM19_61 0 n131 n63 0 0.0046670434360855766
GSUM19_62 0 n131 n64 0 -0.013978126781145381
GSUM19_63 0 n131 n65 0 0.0081397922401475094
GSUM19_64 0 n131 n66 0 -0.016416894425646283
GSUM19_65 0 n131 n67 0 0.047900854381303766
EPCB19 n130 n72 n131 0 1
V_PCB20 n132 n133 0
RSUM20 n134 0 1
GSUM20_11 0 n134 n13 0 0.0087944471069398306
GSUM20_21 0 n134 n23 0 -0.028689829688260393
GSUM20_24 0 n134 n26 0 2.2994565472943039e-06
GSUM20_25 0 n134 n27 0 -1.2214521838022101e-05
GSUM20_26 0 n134 n28 0 0.00010545632764193329
GSUM20_27 0 n134 n29 0 3.3665899134458901e-05
GSUM20_28 0 n134 n30 0 0.0001850481222965636
GSUM20_29 0 n134 n31 0 1.6199603448515551e-05
GSUM20_30 0 n134 n32 0 -0.0043167892383477778
GSUM20_31 0 n134 n33 0 0.0023465395854681205
GSUM20_32 0 n134 n34 0 -0.0035882133695889634
GSUM20_33 0 n134 n35 0 0.0016572193787533292
GSUM20_34 0 n134 n36 0 0.00098231067145543955
GSUM20_35 0 n134 n37 0 -0.00057490898332056306
GSUM20_36 0 n134 n38 0 0.0010810470081615375
GSUM20_37 0 n134 n39 0 -0.00058467643703120149
GSUM20_38 0 n134 n40 0 0.0075055445102941423
GSUM20_39 0 n134 n41 0 0.0015987673775823246
GSUM20_40 0 n134 n42 0 -0.0087056190267899534
GSUM20_41 0 n134 n43 0 0.026709960551551198
GSUM20_42 0 n134 n44 0 0.0019404035540003736
GSUM20_43 0 n134 n45 0 0.0046081875533164791
GSUM20_44 0 n134 n46 0 0.00023995425683846343
GSUM20_45 0 n134 n47 0 0.0010285089340901926
GSUM20_46 0 n134 n48 0 -0.00060671187917472468
GSUM20_47 0 n134 n49 0 0.012785990571889663
GSUM20_48 0 n134 n50 0 -0.0019985677064523052
GSUM20_49 0 n134 n51 0 0.0078241492132730562
GSUM20_50 0 n134 n52 0 0.00031608368521673566
GSUM20_51 0 n134 n53 0 -0.00077800487953865816
GSUM20_52 0 n134 n54 0 -0.00081366252016984452
GSUM20_53 0 n134 n55 0 1.6174443738381246e-05
GSUM20_54 0 n134 n56 0 0.0020976450265348047
GSUM20_55 0 n134 n57 0 0.0013055699824857652
GSUM20_56 0 n134 n58 0 0.012261355313351954
GSUM20_57 0 n134 n59 0 0.023992245591785803
GSUM20_58 0 n134 n60 0 0.001708932915963369
GSUM20_59 0 n134 n61 0 0.00086350876147399847
GSUM20_60 0 n134 n62 0 0.010364207203947521
GSUM20_61 0 n134 n63 0 0.00057559532967914535
GSUM20_62 0 n134 n64 0 0.012473523177532557
GSUM20_63 0 n134 n65 0 0.023669702079605792
GSUM20_64 0 n134 n66 0 0.0010627483714567177
GSUM20_65 0 n134 n67 0 0.043592930167203635
EPCB20 n133 n123 n134 0 1
V_PCB21 n135 n136 0
RSUM21 n137 0 1
GSUM21_0 0 n137 n2 0 -1.0911943257809477e-05
GSUM21_1 0 n137 n3 0 1.7486206407927244e-05
GSUM21_7 0 n137 n9 0 -0.00017482095550549093
GSUM21_9 0 n137 n11 0 -0.0006852920282801613
GSUM21_15 0 n137 n17 0 -0.010039831570937076
GSUM21_17 0 n137 n19 0 -0.0072100117759436883
GSUM21_19 0 n137 n21 0 -0.017302885029456341
GSUM21_24 0 n137 n26 0 8.9030663662580256e-07
GSUM21_25 0 n137 n27 0 7.3415835261541785e-06
GSUM21_26 0 n137 n28 0 -0.00010231174766946633
GSUM21_27 0 n137 n29 0 -4.1878675397098344e-05
GSUM21_28 0 n137 n30 0 -0.00012830999028768894
GSUM21_29 0 n137 n31 0 -1.408548621584393e-05
GSUM21_30 0 n137 n32 0 0.00092023982555583257
GSUM21_31 0 n137 n33 0 -0.00029290284275751161
GSUM21_32 0 n137 n34 0 0.00014292038656204081
GSUM21_33 0 n137 n35 0 0.00039545962006147398
GSUM21_34 0 n137 n36 0 0.00075775488350634341
GSUM21_35 0 n137 n37 0 -0.00023138041161469274
GSUM21_36 0 n137 n38 0 0.0099665470703997946
GSUM21_37 0 n137 n39 0 -0.0033323766639677503
GSUM21_38 0 n137 n40 0 0.019464959179247506
GSUM21_39 0 n137 n41 0 0.0031563410428789478
GSUM21_40 0 n137 n42 0 -0.00014840345704944714
GSUM21_41 0 n137 n43 0 -0.011649446596322412
GSUM21_42 0 n137 n44 0 -0.0068301406329675865
GSUM21_43 0 n137 n45 0 -0.0014915461985034455
GSUM21_44 0 n137 n46 0 0.0024705610736398824
GSUM21_45 0 n137 n47 0 0.0035286805401141155
GSUM21_46 0 n137 n48 0 0.00042424953089519496
GSUM21_47 0 n137 n49 0 0.0035254672967464625
GSUM21_48 0 n137 n50 0 -0.0032249249767068461
GSUM21_49 0 n137 n51 0 -0.019917294747840621
GSUM21_50 0 n137 n52 0 0.0020097870886381444
GSUM21_51 0 n137 n53 0 -0.0027811227082713708
GSUM21_52 0 n137 n54 0 -0.0076241709349469892
GSUM21_53 0 n137 n55 0 -0.00083028963035348252
GSUM21_54 0 n137 n56 0 0.012606925576701549
GSUM21_55 0 n137 n57 0 -0.0064512379513076779
GSUM21_56 0 n137 n58 0 0.016360185551378567
GSUM21_57 0 n137 n59 0 -0.013443818138983063
GSUM21_58 0 n137 n60 0 0.010687953645004578
GSUM21_59 0 n137 n61 0 0.0031920804310729477
GSUM21_60 0 n137 n62 0 0.017090050363410318
GSUM21_61 0 n137 n63 0 0.0010088743971412302
GSUM21_62 0 n137 n64 0 -0.0058090973072167729
GSUM21_63 0 n137 n65 0 -0.012731164652664499
GSUM21_64 0 n137 n66 0 -0.035602776449485556
GSUM21_65 0 n137 n67 0 -0.053901807783185166
EPCB21 n136 0 n137 0 1
V_PCB22 n138 n139 0
RSUM22 n140 0 1
GSUM22_5 0 n140 n7 0 -0.00048561431381850573
GSUM22_13 0 n140 n15 0 -0.010110842731773857
GSUM22_16 0 n140 n18 0 0.0082746478439628141
GSUM22_22 0 n140 n24 0 0.014224563090461037
GSUM22_24 0 n140 n26 0 3.0008421619377159e-05
GSUM22_25 0 n140 n27 0 1.4589746596349736e-05
GSUM22_26 0 n140 n28 0 5.5954973348254598e-06
GSUM22_27 0 n140 n29 0 -4.8017612804888327e-05
GSUM22_28 0 n140 n30 0 0.00035939202166654122
GSUM22_29 0 n140 n31 0 0.0003970499662255642
GSUM22_30 0 n140 n32 0 0.00012639797891922036
GSUM22_31 0 n140 n33 0 0.0009155606398032161
GSUM22_32 0 n140 n34 0 0.00082726070391387035
GSUM22_33 0 n140 n35 0 -0.0013419201100467494
GSUM22_34 0 n140 n36 0 0.0085313361483195412
GSUM22_35 0 n140 n37 0 0.0064597047223569999
GSUM22_36 0 n140 n38 0 -0.0017708568775368712
GSUM22_37 0 n140 n39 0 -0.000305004084838522
GSUM22_38 0 n140 n40 0 0.0028542369465231325
GSUM22_39 0 n140 n41 0 -0.0076506854790916934
GSUM22_40 0 n140 n42 0 0.0003837438751699687
GSUM22_41 0 n140 n43 0 -0.00055083555691865058
GSUM22_42 0 n140 n44 0 -0.0012693510861642287
GSUM22_43 0 n140 n45 0 6.0811712934832952e-05
GSUM22_44 0 n140 n46 0 0.0015908489788624878
GSUM22_45 0 n140 n47 0 -0.0015484798124818483
GSUM22_46 0 n140 n48 0 -0.00036158011919996161
GSUM22_47 0 n140 n49 0 0.00045608127101783708
GSUM22_48 0 n140 n50 0 -0.00059763696793022634
GSUM22_49 0 n140 n51 0 -0.0018348184460899913
GSUM22_50 0 n140 n52 0 -0.0017739043717040694
GSUM22_51 0 n140 n53 0 0.00069070701389949997
GSUM22_52 0 n140 n54 0 0.00075370877135724854
GSUM22_53 0 n140 n55 0 -0.00053170836088456809
GSUM22_54 0 n140 n56 0 0.0038358012167383848
GSUM22_55 0 n140 n57 0 0.0055859327712820339
GSUM22_56 0 n140 n58 0 -0.00050216811361891581
GSUM22_57 0 n140 n59 0 -0.00056561233525230883
GSUM22_58 0 n140 n60 0 0.0010988836123684575
GSUM22_59 0 n140 n61 0 0.00051100140414079035
GSUM22_60 0 n140 n62 0 0.002148893041136391
GSUM22_61 0 n140 n63 0 -0.0075023171505812034
GSUM22_62 0 n140 n64 0 -0.0025016682089578253
GSUM22_63 0 n140 n65 0 0.00047934672132791701
GSUM22_64 0 n140 n66 0 0.020974171653943406
GSUM22_65 0 n140 n67 0 -0.0028040340202721017
EPCB22 n139 n107 n140 0 1
V_PCB23 n141 n142 0
RSUM23 n143 0 1
GSUM23_0 0 n143 n2 0 -1.2081379347035953e-05
GSUM23_1 0 n143 n3 0 -9.6906176342760771e-06
GSUM23_7 0 n143 n9 0 -0.00013467942335999015
GSUM23_9 0 n143 n11 0 -0.00011728868745521581
GSUM23_15 0 n143 n17 0 0.010446099504259607
GSUM23_17 0 n143 n19 0 -0.005655655537359929
GSUM23_19 0 n143 n21 0 -0.017844454315293877
GSUM23_24 0 n143 n26 0 -1.1265718370523288e-05
GSUM23_25 0 n143 n27 0 1.1049228098674127e-05
GSUM23_26 0 n143 n28 0 -2.3406116692165956e-05
GSUM23_27 0 n143 n29 0 5.3609306545773738e-05
GSUM23_28 0 n143 n30 0 -0.00045424092245335232
GSUM23_29 0 n143 n31 0 3.3880665133994019e-05
GSUM23_30 0 n143 n32 0 3.1467502882147301e-07
GSUM23_31 0 n143 n33 0 0.0004500001108347635
GSUM23_32 0 n143 n34 0 0.00021778741469197284
GSUM23_33 0 n143 n35 0 0.00097127378379953996
GSUM23_34 0 n143 n36 0 -0.0017777295639038381
GSUM23_35 0 n143 n37 0 -4.3773456020440162e-05
GSUM23_36 0 n143 n38 0 -0.010160397338077803
GSUM23_37 0 n143 n39 0 -0.0025290018925138115
GSUM23_38 0 n143 n40 0 0.01951552068161997
GSUM23_39 0 n143 n41 0 0.0033009399278994627
GSUM23_40 0 n143 n42 0 0.00048845949586583668
GSUM23_41 0 n143 n43 0 -0.0082985456287702469
GSUM23_42 0 n143 n44 0 -0.0079740855233196416
GSUM23_43 0 n143 n45 0 0.0012492133175473112
GSUM23_44 0 n143 n46 0 0.0017312283424032152
GSUM23_45 0 n143 n47 0 0.0013052647632635324
GSUM23_46 0 n143 n48 0 -0.000169609368249868
GSUM23_47 0 n143 n49 0 0.0049672547793139857
GSUM23_48 0 n143 n50 0 -0.00807149232201799
GSUM23_49 0 n143 n51 0 -0.01961137352748106
GSUM23_50 0 n143 n52 0 -0.0013568233871662056
GSUM23_51 0 n143 n53 0 0.0016823880505833055
GSUM23_52 0 n143 n54 0 0.0098870528026774717
GSUM23_53 0 n143 n55 0 -0.0011850995411065847
GSUM23_54 0 n143 n56 0 0.010605258752103278
GSUM23_55 0 n143 n57 0 -0.006394785784593425
GSUM23_56 0 n143 n58 0 0.014274757370759658
GSUM23_57 0 n143 n59 0 -0.0095994564529863231
GSUM23_58 0 n143 n60 0 -0.0053800259966535254
GSUM23_59 0 n143 n61 0 0.0030600565155370477
GSUM23_60 0 n143 n62 0 0.02013571277638642
GSUM23_61 0 n143 n63 0 0.0028915068530580854
GSUM23_62 0 n143 n64 0 -0.0070139062239196479
GSUM23_63 0 n143 n65 0 -0.0080936060590659081
GSUM23_64 0 n143 n66 0 -0.039467477207246186
GSUM23_65 0 n143 n67 0 -0.049414768744129339
EPCB23 n142 0 n143 0 1
VSUP n144 0 24
V_RSOURCE n144 n145 0
R_RSOURCE n145 n146 0.050000000000000003
V_LSOURCE n146 n147 0
L_LSOURCE n147 n148 9.9999999999999995e-08 IC=0.22497333333333333
V_C19 n68 n149 0
R_C19_series n149 n150 0.0050000000000000001
L_C19_series n150 n151 8.0000000000000003e-10
C_C19 n151 n71 9.9999999999999995e-07 IC=-23.980877266666667
V_C20 0 n152 0
R_C20_series n152 n153 0.0050000000000000001
L_C20_series n153 n154 8.0000000000000003e-10
C_C20 n154 n75 1.0000000000000001e-05 IC=-23.980877266666667
V_C21 n78 n155 0
R_C21_series n155 n156 0.0050000000000000001
L_C21_series n156 n157 8.0000000000000003e-10
C_C21 n157 n81 1.0000000000000001e-05 IC=-23.980877266666667
V_C22 n84 n158 0
R_C22_series n158 n159 0.0050000000000000001
L_C22_series n159 n160 8.0000000000000003e-10
C_C22 n160 n87 1.0000000000000001e-05 IC=-23.980877266666667
V_C23 n90 n161 0
R_C23_series n161 n162 0.0050000000000000001
L_C23_series n162 n163 8.0000000000000003e-10
C_C23 n163 n93 1.0000000000000001e-05 IC=-23.980877266666667
V_C24 n96 n164 0
R_C24_series n164 n165 0.0050000000000000001
L_C24_series n165 n166 8.0000000000000003e-10
C_C24 n166 n99 9.9999999999999995e-07 IC=-23.980877266666667
V_C25 n102 n167 0
R_C25_series n167 n168 0.014999999999999999
L_C25_series n168 n169 8.0000000000000003e-10
C_C25 n169 n106 3.2999999999999998e-08 IC=-8.2689215651607277
V_C27 n110 n170 0
R_C27_series n170 n171 0.014999999999999999
L_C27_series n171 n172 8.0000000000000003e-10
C_C27 n172 n113 3.2999999999999998e-08 IC=-8.2689215651607277
V_C30 n116 n173 0
R_C30_series n173 n174 0.014999999999999999
L_C30_series n174 n175 8.0000000000000003e-10
C_C30 n175 n119 3.2999999999999998e-08 IC=-8.2689215651607277
V_R9 n148 n176 0
R_R9 n176 n177 0.0050000000000000001
V_L3 n177 n178 0
R_L3_series n178 n179 0.029999999999999999
L_L3 n179 n72 5.5999999999999997e-06 IC=0.22497333333333333
V_CA1 n177 n180 0
R_CA1_series n180 n181 0.02
L_CA1_series n181 n182 1.0000000000000001e-09
C_CA1 n182 0 2.1999999999999999e-05 IC=23.987626466666665
V_CA2 n177 n183 0
R_CA2_series n183 n184 0.02
L_CA2_series n184 n185 1.0000000000000001e-09
C_CA2 n185 0 2.1999999999999999e-05 IC=23.987626466666665
V_CA3 n177 n186 0
R_CA3_series n186 n187 0.02
L_CA3_series n187 n188 1.0000000000000001e-09
C_CA3 n188 0 2.1999999999999999e-05 IC=23.987626466666665
V_CA4 n177 n189 0
R_CA4_series n189 n190 0.02
L_CA4_series n190 n191 1.0000000000000001e-09
C_CA4 n191 0 2.1999999999999999e-05 IC=23.987626466666665
V_Q1 n126 n192 0
VG_Q1 n194 n122 PULSE(0 10 1.2708076991739954e-06 2e-08 2e-08 5.4355555555555561e-06 1.1111111111111112e-05)
RG_Q1 n194 n193 2
L_Q1_d n192 n195 1.0000000000000001e-09
L_Q1_s n122 n196 5.0000000000000003e-10
.model NM_Q1 VDMOS(VTO=3 KP=17.857142857142858 RDS=10000000000 CGDMIN=5.0000000000000002e-11 CGDMAX=5.0000000000000002e-11 CGS=1.0000000000000001e-09 CJO=5.0000000000000003e-10 TT=2e-08 RB=0.02 IS=9.9999999999999998e-13)
M_Q1 n195 n193 n196 NM_Q1
V_Q2 n129 n197 0
VG_Q2 n199 n107 PULSE(0 10 4.9999999999999998e-08 2e-08 2e-08 5.4355555555555561e-06 1.1111111111111112e-05)
RG_Q2 n199 n198 2
L_Q2_d n197 n200 1.0000000000000001e-09
L_Q2_s n107 n201 5.0000000000000003e-10
.model NM_Q2 VDMOS(VTO=3 KP=17.857142857142858 RDS=10000000000 CGDMIN=5.0000000000000002e-11 CGDMAX=5.0000000000000002e-11 CGS=1.0000000000000001e-09 CJO=5.0000000000000003e-10 TT=2e-08 RB=0.02 IS=9.9999999999999998e-13)
M_Q2 n200 n198 n201 NM_Q2
V_Q3 n132 n202 0
VG_Q3 n204 n135 PULSE(0 10 6.8263632547295515e-06 2e-08 2e-08 5.4355555555555561e-06 1.1111111111111112e-05)
RG_Q3 n204 n203 2
L_Q3_d n202 n205 1.0000000000000001e-09
L_Q3_s n135 n206 5.0000000000000003e-10
.model NM_Q3 VDMOS(VTO=3 KP=17.857142857142858 RDS=10000000000 CGDMIN=5.0000000000000002e-11 CGDMAX=5.0000000000000002e-11 CGS=1.0000000000000001e-09 CJO=5.0000000000000003e-10 TT=2e-08 RB=0.02 IS=9.9999999999999998e-13)
M_Q3 n205 n203 n206 NM_Q3
V_Q4 n138 n207 0
VG_Q4 n209 n141 PULSE(0 10 5.6055555555555562e-06 2e-08 2e-08 5.4355555555555561e-06 1.1111111111111112e-05)
RG_Q4 n209 n208 2
L_Q4_d n207 n210 1.0000000000000001e-09
L_Q4_s n141 n211 5.0000000000000003e-10
.model NM_Q4 VDMOS(VTO=3 KP=17.857142857142858 RDS=10000000000 CGDMIN=5.0000000000000002e-11 CGDMAX=5.0000000000000002e-11 CGS=1.0000000000000001e-09 CJO=5.0000000000000003e-10 TT=2e-08 RB=0.02 IS=9.9999999999999998e-13)
M_Q4 n210 n208 n211 NM_Q4
V_PRIMARY n103 n212 0
R_PRIMARY n212 n213 0.11
L_PRIMARY n213 n123 2.4000000000000001e-05 IC=0.98912357065742762
C_PRIMARY_self n212 n123 1.7801129975954663e-11 IC=4.0991460895513301
R_PRIMARY_core n213 n123 30773.183367301404
V_SECONDARY 0 n215 0
R_SECONDARY n215 n217 0.11
L_SECONDARY n217 n216 2.4000000000000001e-05 IC=0.66447918721363597
C_SECONDARY_self n215 n216 1.7801129975954663e-11 IC=14.185887757674928
R_SECONDARY_core n217 n216 30773.183367301404
KLINK L_PRIMARY L_SECONDARY 0.40000000000000002
V_CSECONDARY n216 n218 0
R_CSECONDARY_series n218 n220 0.014999999999999999
L_CSECONDARY_series n220 n221 8.0000000000000003e-10
C_CSECONDARY n221 n219 1.3027926527986091e-07 IC=-17.950095449877416
V_LOAD n219 n222 0
R_LOAD n222 0 5.6498993145849434
.ic V(n177)=23.987626466666665
.ic V(n72)=23.980877266666667
.options method=gear maxord=2 reltol=1e-4 abstol=1e-9 vntol=1e-6 chgtol=1e-12 gmin=1e-10 rshunt=1e12
.control
set klu
set wr_singlescale
set wr_vecnames
save i(L_PRIMARY) i(L_SECONDARY) i(VG_Q1) i(VG_Q2) i(VG_Q3) i(VG_Q4) i(VSUP) i(V_C19) i(V_C20) i(V_C21) i(V_C22) i(V_C23) i(V_C24) i(V_C25) i(V_C27) i(V_C30) i(V_CA1) i(V_CA2) i(V_CA3) i(V_CA4) i(V_CSECONDARY) i(V_L3) i(V_LOAD) i(V_LSOURCE) i(V_PCB0) i(V_PCB1) i(V_PCB10) i(V_PCB11) i(V_PCB12) i(V_PCB13) i(V_PCB14) i(V_PCB15) i(V_PCB16) i(V_PCB17) i(V_PCB18) i(V_PCB19) i(V_PCB2) i(V_PCB20) i(V_PCB21) i(V_PCB22) i(V_PCB23) i(V_PCB3) i(V_PCB4) i(V_PCB5) i(V_PCB6) i(V_PCB7) i(V_PCB8) i(V_PCB9) i(V_PRIMARY) i(V_Q1) i(V_Q2) i(V_Q3) i(V_Q4) i(V_R9) i(V_RSOURCE) i(V_SECONDARY) v(n102) v(n103) v(n106) v(n107) v(n110) v(n113) v(n116) v(n119) v(n122) v(n123) v(n126) v(n129) v(n132) v(n135) v(n138) v(n141) v(n144) v(n146) v(n148) v(n177) v(n194) v(n199) v(n204) v(n209) v(n216) v(n219) v(n68) v(n71) v(n72) v(n75) v(n78) v(n81) v(n84) v(n87) v(n90) v(n93) v(n96) v(n99)
tran 4.340277777777778e-08 0.00057777777777777775 0 4.340277777777778e-08 uic
let out0=v(n68)
let out1=i(V_PCB0)
let out2=v(n71,n72)
let out3=i(V_PCB1)
let out4=v(n75,n72)
let out5=i(V_PCB2)
let out6=v(n78)
let out7=i(V_PCB3)
let out8=v(n81,n72)
let out9=i(V_PCB4)
let out10=v(n84)
let out11=i(V_PCB5)
let out12=v(n87,n72)
let out13=i(V_PCB6)
let out14=v(n90)
let out15=i(V_PCB7)
let out16=v(n93,n72)
let out17=i(V_PCB8)
let out18=v(n96)
let out19=i(V_PCB9)
let out20=v(n99,n72)
let out21=i(V_PCB10)
let out22=v(n102,n103)
let out23=i(V_PCB11)
let out24=v(n106,n107)
let out25=i(V_PCB12)
let out26=v(n110,n103)
let out27=i(V_PCB13)
let out28=v(n113,n107)
let out29=i(V_PCB14)
let out30=v(n116,n103)
let out31=i(V_PCB15)
let out32=v(n119,n107)
let out33=i(V_PCB16)
let out34=v(n122,n123)
let out35=i(V_PCB17)
let out36=v(n126,n72)
let out37=i(V_PCB18)
let out38=v(n129,n72)
let out39=i(V_PCB19)
let out40=v(n132,n123)
let out41=i(V_PCB20)
let out42=v(n135)
let out43=i(V_PCB21)
let out44=v(n138,n107)
let out45=i(V_PCB22)
let out46=v(n141)
let out47=i(V_PCB23)
let out48=i(VSUP)
let out49=v(n144)
let out50=i(V_RSOURCE)
let out51=v(n144,n146)
let out52=i(V_LSOURCE)
let out53=v(n146,n148)
let out54=i(V_C19)
let out55=v(n68,n71)
let out56=i(V_C20)
let out57=v(n75)
let out58=i(V_C21)
let out59=v(n78,n81)
let out60=i(V_C22)
let out61=v(n84,n87)
let out62=i(V_C23)
let out63=v(n90,n93)
let out64=i(V_C24)
let out65=v(n96,n99)
let out66=i(V_C25)
let out67=v(n102,n106)
let out68=i(V_C27)
let out69=v(n110,n113)
let out70=i(V_C30)
let out71=v(n116,n119)
let out72=i(V_R9)
let out73=v(n148,n177)
let out74=i(V_L3)
let out75=v(n177,n72)
let out76=i(V_CA1)
let out77=v(n177)
let out78=i(V_CA2)
let out79=v(n177)
let out80=i(V_CA3)
let out81=v(n177)
let out82=i(V_CA4)
let out83=v(n177)
let out84=i(V_Q1)
let out85=v(n126,n122)
let out86=i(VG_Q1)
let out87=v(n194,n122)
let out88=i(V_Q2)
let out89=v(n129,n107)
let out90=i(VG_Q2)
let out91=v(n199,n107)
let out92=i(V_Q3)
let out93=v(n132,n135)
let out94=i(VG_Q3)
let out95=v(n204,n135)
let out96=i(V_Q4)
let out97=v(n138,n141)
let out98=i(VG_Q4)
let out99=v(n209,n141)
let out100=i(V_PRIMARY)
let out101=i(L_PRIMARY)
let out102=v(n103,n123)
let out103=i(V_SECONDARY)
let out104=i(L_SECONDARY)
let out105=v(n216)
let out106=i(V_CSECONDARY)
let out107=v(n216,n219)
let out108=i(V_LOAD)
let out109=v(n219)
let out110=v(n219)
let out111=v(n72)
let out112=v(n177)
let out113=v(n107,n122)
let measure0=-(1*out49)*(1*out48)
meas tran m0 AVG measure0 from=0.0005666666666666666 to=0.00057777777777777775
let measure1=(1*out110)^2/5.6498993145849434
meas tran m1 AVG measure1 from=0.0005666666666666666 to=0.00057777777777777775
let measure2=(1*out101)
meas tran m2 RMS measure2 from=0.0005666666666666666 to=0.00057777777777777775
let measure3=(1*out104)
meas tran m3 RMS measure3 from=0.0005666666666666666 to=0.00057777777777777775
let measure4=abs((1*out101))
meas tran m4 MAX measure4 from=0.0005666666666666666 to=0.00057777777777777775
let measure5=(1*out111)
meas tran m5 PP measure5 from=0.0005666666666666666 to=0.00057777777777777775
let measure6=-(1*out87)*(1*out86)+-(1*out91)*(1*out90)+-(1*out95)*(1*out94)+-(1*out99)*(1*out98)
meas tran m6 AVG measure6 from=0.0005666666666666666 to=0.00057777777777777775
let measure7=(1*out0)*(1*out1)
meas tran m7 AVG measure7 from=0.0005666666666666666 to=0.00057777777777777775
let measure8=(1*out2)*(1*out3)
meas tran m8 AVG measure8 from=0.0005666666666666666 to=0.00057777777777777775
let measure9=(1*out4)*(1*out5)
meas tran m9 AVG measure9 from=0.0005666666666666666 to=0.00057777777777777775
let measure10=(1*out6)*(1*out7)
meas tran m10 AVG measure10 from=0.0005666666666666666 to=0.00057777777777777775
let measure11=(1*out8)*(1*out9)
meas tran m11 AVG measure11 from=0.0005666666666666666 to=0.00057777777777777775
let measure12=(1*out10)*(1*out11)
meas tran m12 AVG measure12 from=0.0005666666666666666 to=0.00057777777777777775
let measure13=(1*out12)*(1*out13)
meas tran m13 AVG measure13 from=0.0005666666666666666 to=0.00057777777777777775
let measure14=(1*out14)*(1*out15)
meas tran m14 AVG measure14 from=0.0005666666666666666 to=0.00057777777777777775
let measure15=(1*out16)*(1*out17)
meas tran m15 AVG measure15 from=0.0005666666666666666 to=0.00057777777777777775
let measure16=(1*out18)*(1*out19)
meas tran m16 AVG measure16 from=0.0005666666666666666 to=0.00057777777777777775
let measure17=(1*out20)*(1*out21)
meas tran m17 AVG measure17 from=0.0005666666666666666 to=0.00057777777777777775
let measure18=(1*out22)*(1*out23)
meas tran m18 AVG measure18 from=0.0005666666666666666 to=0.00057777777777777775
let measure19=(1*out24)*(1*out25)
meas tran m19 AVG measure19 from=0.0005666666666666666 to=0.00057777777777777775
let measure20=(1*out26)*(1*out27)
meas tran m20 AVG measure20 from=0.0005666666666666666 to=0.00057777777777777775
let measure21=(1*out28)*(1*out29)
meas tran m21 AVG measure21 from=0.0005666666666666666 to=0.00057777777777777775
let measure22=(1*out30)*(1*out31)
meas tran m22 AVG measure22 from=0.0005666666666666666 to=0.00057777777777777775
let measure23=(1*out32)*(1*out33)
meas tran m23 AVG measure23 from=0.0005666666666666666 to=0.00057777777777777775
let measure24=(1*out34)*(1*out35)
meas tran m24 AVG measure24 from=0.0005666666666666666 to=0.00057777777777777775
let measure25=(1*out36)*(1*out37)
meas tran m25 AVG measure25 from=0.0005666666666666666 to=0.00057777777777777775
let measure26=(1*out38)*(1*out39)
meas tran m26 AVG measure26 from=0.0005666666666666666 to=0.00057777777777777775
let measure27=(1*out40)*(1*out41)
meas tran m27 AVG measure27 from=0.0005666666666666666 to=0.00057777777777777775
let measure28=(1*out42)*(1*out43)
meas tran m28 AVG measure28 from=0.0005666666666666666 to=0.00057777777777777775
let measure29=(1*out44)*(1*out45)
meas tran m29 AVG measure29 from=0.0005666666666666666 to=0.00057777777777777775
let measure30=(1*out46)*(1*out47)
meas tran m30 AVG measure30 from=0.0005666666666666666 to=0.00057777777777777775
let measure31=(1*out51)*(1*out50)
meas tran m31 AVG measure31 from=0.0005666666666666666 to=0.00057777777777777775
let measure32=(1*out53)*(1*out52)
meas tran m32 AVG measure32 from=0.0005666666666666666 to=0.00057777777777777775
let measure33=(1*out55)*(1*out54)
meas tran m33 AVG measure33 from=0.0005666666666666666 to=0.00057777777777777775
let measure34=(-1*out57)*(1*out56)
meas tran m34 AVG measure34 from=0.0005666666666666666 to=0.00057777777777777775
let measure35=(1*out59)*(1*out58)
meas tran m35 AVG measure35 from=0.0005666666666666666 to=0.00057777777777777775
let measure36=(1*out61)*(1*out60)
meas tran m36 AVG measure36 from=0.0005666666666666666 to=0.00057777777777777775
let measure37=(1*out63)*(1*out62)
meas tran m37 AVG measure37 from=0.0005666666666666666 to=0.00057777777777777775
let measure38=(1*out65)*(1*out64)
meas tran m38 AVG measure38 from=0.0005666666666666666 to=0.00057777777777777775
let measure39=(1*out67)*(1*out66)
meas tran m39 AVG measure39 from=0.0005666666666666666 to=0.00057777777777777775
let measure40=(1*out69)*(1*out68)
meas tran m40 AVG measure40 from=0.0005666666666666666 to=0.00057777777777777775
let measure41=(1*out71)*(1*out70)
meas tran m41 AVG measure41 from=0.0005666666666666666 to=0.00057777777777777775
let measure42=(1*out73)*(1*out72)
meas tran m42 AVG measure42 from=0.0005666666666666666 to=0.00057777777777777775
let measure43=(1*out75)*(1*out74)
meas tran m43 AVG measure43 from=0.0005666666666666666 to=0.00057777777777777775
let measure44=(1*out77)*(1*out76)
meas tran m44 AVG measure44 from=0.0005666666666666666 to=0.00057777777777777775
let measure45=(1*out79)*(1*out78)
meas tran m45 AVG measure45 from=0.0005666666666666666 to=0.00057777777777777775
let measure46=(1*out81)*(1*out80)
meas tran m46 AVG measure46 from=0.0005666666666666666 to=0.00057777777777777775
let measure47=(1*out83)*(1*out82)
meas tran m47 AVG measure47 from=0.0005666666666666666 to=0.00057777777777777775
let measure48=(1*out85)*(1*out84)
meas tran m48 AVG measure48 from=0.0005666666666666666 to=0.00057777777777777775
let measure49=(1*out89)*(1*out88)
meas tran m49 AVG measure49 from=0.0005666666666666666 to=0.00057777777777777775
let measure50=(1*out93)*(1*out92)
meas tran m50 AVG measure50 from=0.0005666666666666666 to=0.00057777777777777775
let measure51=(1*out97)*(1*out96)
meas tran m51 AVG measure51 from=0.0005666666666666666 to=0.00057777777777777775
let measure52=(1*out102)*(1*out100)
meas tran m52 AVG measure52 from=0.0005666666666666666 to=0.00057777777777777775
let measure53=(-1*out105)*(1*out103)
meas tran m53 AVG measure53 from=0.0005666666666666666 to=0.00057777777777777775
let measure54=(1*out107)*(1*out106)
meas tran m54 AVG measure54 from=0.0005666666666666666 to=0.00057777777777777775
let measure55=(1*out109)*(1*out108)
meas tran m55 AVG measure55 from=0.0005666666666666666 to=0.00057777777777777775
linearize out0 out1 out2 out3 out4 out5 out6 out7 out8 out9 out10 out11 out12 out13 out14 out15 out16 out17 out18 out19 out20 out21 out22 out23 out24 out25 out26 out27 out28 out29 out30 out31 out32 out33 out34 out35 out36 out37 out38 out39 out40 out41 out42 out43 out44 out45 out46 out47 out48 out49 out50 out51 out52 out53 out54 out55 out56 out57 out58 out59 out60 out61 out62 out63 out64 out65 out66 out67 out68 out69 out70 out71 out72 out73 out74 out75 out76 out77 out78 out79 out80 out81 out82 out83 out84 out85 out86 out87 out88 out89 out90 out91 out92 out93 out94 out95 out96 out97 out98 out99 out100 out101 out102 out103 out104 out105 out106 out107 out108 out109 out110 out111 out112 out113
wrdata transient.dat out0 out1 out2 out3 out4 out5 out6 out7 out8 out9 out10 out11 out12 out13 out14 out15 out16 out17 out18 out19 out20 out21 out22 out23 out24 out25 out26 out27 out28 out29 out30 out31 out32 out33 out34 out35 out36 out37 out38 out39 out40 out41 out42 out43 out44 out45 out46 out47 out48 out49 out50 out51 out52 out53 out54 out55 out56 out57 out58 out59 out60 out61 out62 out63 out64 out65 out66 out67 out68 out69 out70 out71 out72 out73 out74 out75 out76 out77 out78 out79 out80 out81 out82 out83 out84 out85 out86 out87 out88 out89 out90 out91 out92 out93 out94 out95 out96 out97 out98 out99 out100 out101 out102 out103 out104 out105 out106 out107 out108 out109 out110 out111 out112 out113
quit
.endc
.end
